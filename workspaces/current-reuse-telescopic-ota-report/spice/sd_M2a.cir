* single-device op check: M2a (pmos), N=1 parallel unit fingers

.include "C:/pdk/sky130_fd_pr/cells/pfet_01v8/sky130_fd_pr__pfet_01v8__tt.pm3.spice"
.include "C:/pdk/sky130_fd_pr/cells/pfet_01v8/sky130_fd_pr__pfet_01v8__mismatch.corner.spice"
.include "C:/pdk/sky130_fd_pr/models/parameters/lod.spice"

Vg g 0 -0.857426
Vd d 0 -0.200000
Vsrc s 0 0
Vb b 0 0
XM0 d g s b sky130_fd_pr__pfet_01v8 l=0.150000u w=4.125643u
.op
.control
run
print @m.xm0.msky130_fd_pr__pfet_01v8[id]
print @m.xm0.msky130_fd_pr__pfet_01v8[gm]
print @m.xm0.msky130_fd_pr__pfet_01v8[vdsat]
print @m.xm0.msky130_fd_pr__pfet_01v8[vth]
print -i(vd)
.endc
.end
