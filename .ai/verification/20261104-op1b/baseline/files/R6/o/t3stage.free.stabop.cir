* spice_oracle: t3stage bias=free
.include "C:/pdk/sky130_fd_pr/cells/nfet_01v8/sky130_fd_pr__nfet_01v8__tt.pm3.spice"
.include "C:/pdk/sky130_fd_pr/cells/nfet_01v8/sky130_fd_pr__nfet_01v8__mismatch.corner.spice"
.temp 27
.option gmin=1e-15 reltol=1e-4 abstol=1e-14 vntol=1e-7
Vrail_vdd vdd 0 DC 1.8
XM1 n1 nin 0 0 sky130_fd_pr__nfet_01v8 l=5e-07 w=2e-06 m=2 ad=0 as=0 pd=0 ps=0
XM2 n2 n1 0 0 sky130_fd_pr__nfet_01v8 l=5e-07 w=2e-06 m=2 ad=0 as=0 pd=0 ps=0
XM3 n3 n2 0 0 sky130_fd_pr__nfet_01v8 l=5e-07 w=2e-06 m=2 ad=0 as=0 pd=0 ps=0
Rp_R1 vdd n1 129409.146
Rp_R2 vdd n2 129409.146
Rp_R3 vdd n3 129409.146
Cp_C1 n1 0 1e-09
Cp_C2 n2 0 1e-12
Cp_C3 n3 0 1e-12
Vdc_nin dcs_nin 0 DC 0.7
Ldc_nin dcs_nin nin 1e+12
Cac_nin nin acs_nin 1
Vac_nin acs_nin 0 DC 0 AC 1
.control
set noaskquit
op
echo OPSTART
print i(ldc_nin)
print v(nin)
print v(n3)
echo OPEND
quit
.endc
.end
