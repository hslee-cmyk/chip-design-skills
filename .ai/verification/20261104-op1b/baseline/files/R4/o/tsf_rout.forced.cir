* spice_oracle: tsf_rout bias=forced
.include "C:/pdk/sky130_fd_pr/cells/nfet_01v8/sky130_fd_pr__nfet_01v8__tt.pm3.spice"
.include "C:/pdk/sky130_fd_pr/cells/nfet_01v8/sky130_fd_pr__nfet_01v8__mismatch.corner.spice"
.temp 27
.option gmin=1e-15 reltol=1e-4 abstol=1e-14 vntol=1e-7
Vrail_vdd vdd 0 DC 1.8
XM1 vdd nin nout 0 sky130_fd_pr__nfet_01v8 l=5e-07 w=2e-06 m=2 ad=0 as=0 pd=0 ps=0
Rp_RS nout 0 10000
Vdc_nin dcs_nin 0 DC 1.2
Ldc_nin dcs_nin nin 1e+12
Cac_nin nin acs_nin 1
Vac_nin acs_nin 0 DC 0 AC 1
Vhold_nout hs_nout 0 DC 0.3328003
Lhold_nout hs_nout nout 1e+12
Irout_0 0 nout DC 0 AC 0
.control
set noaskquit
op
echo OPSTART
print @m.xm1.msky130_fd_pr__nfet_01v8[id]
print @m.xm1.msky130_fd_pr__nfet_01v8[gm]
print @m.xm1.msky130_fd_pr__nfet_01v8[gds]
print @m.xm1.msky130_fd_pr__nfet_01v8[vth]
print @m.xm1.msky130_fd_pr__nfet_01v8[vdsat]
print @m.xm1.msky130_fd_pr__nfet_01v8[vgs]
print @m.xm1.msky130_fd_pr__nfet_01v8[vds]
print @m.xm1.msky130_fd_pr__nfet_01v8[vbs]
print v(vdd)
print v(nin)
print v(nout)
print i(vrail_vdd)
print i(vhold_nout)
echo OPEND
ac dec 40 0.01 1e+10
let hout = v(nout)
set wr_singlescale
wrdata tsf_rout.forced.ac.txt hout
set wr_singlescale
alter @vac_nin[acmag] = 0
alter @vrail_vdd[acmag] = 0
alter @irout_0[acmag] = 1
ac lin 1 0.01 0.01
let hrout0 = v(nout)
wrdata tsf_rout.forced.rout0.txt hrout0
quit
.endc
.end
