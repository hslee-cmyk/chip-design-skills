* spice_oracle: trhp_posfb bias=forced
.include "C:/pdk/sky130_fd_pr/cells/nfet_01v8/sky130_fd_pr__nfet_01v8__tt.pm3.spice"
.include "C:/pdk/sky130_fd_pr/cells/nfet_01v8/sky130_fd_pr__nfet_01v8__mismatch.corner.spice"
.temp 27
.option gmin=1e-15 reltol=1e-4 abstol=1e-14 vntol=1e-7
Vrail_vdd vdd 0 DC 1.8
Vrail_vb vb 0 DC 0.7
XM1 n1 nin 0 0 sky130_fd_pr__nfet_01v8 l=5e-07 w=2e-06 m=1 ad=0 as=0 pd=0 ps=0
XM2 n2 n1 0 0 sky130_fd_pr__nfet_01v8 l=5e-07 w=2e-06 m=2 ad=0 as=0 pd=0 ps=0
XM3 n1 n3 0 0 sky130_fd_pr__nfet_01v8 l=5e-07 w=2e-06 m=4 ad=0 as=0 pd=0 ps=0
Rp_R1 vdd n1 51764.70588
Rp_R2 vdd n2 129400
Rp_Rb vb n3 100000
Cp_Cc n2 n3 1e-12
Vhold_n1 hs_n1 0 DC 0.6999804
Itb_Lhold_n1 hs_n1 n1 DC -6.70027e-13
Vhold_n2 hs_n2 0 DC 0.700376
Itb_Lhold_n2 hs_n2 n2 DC -4.26544e-12
Vhold_n3 hs_n3 0 DC 0.7
Itb_Lhold_n3 hs_n3 n3 DC 0
Vpz_nin nin 0 DC 0.7
.nodeset v(n1)=0.6999804
.nodeset v(n2)=0.700376
.nodeset v(n3)=0.7
.control
set noaskquit
op
echo PZSTART
pz n2 0 n2 0 cur pol
print all
echo PZEND
quit
.endc
.end
