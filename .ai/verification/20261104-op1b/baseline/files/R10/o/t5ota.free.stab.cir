* spice_oracle: t5ota bias=free
.include "C:/pdk/sky130_fd_pr/cells/nfet_01v8/sky130_fd_pr__nfet_01v8__tt.pm3.spice"
.include "C:/pdk/sky130_fd_pr/cells/nfet_01v8/sky130_fd_pr__nfet_01v8__mismatch.corner.spice"
.include "C:/pdk/sky130_fd_pr/models/parameters/lod.spice"
.include "C:/pdk/sky130_fd_pr/cells/pfet_01v8/sky130_fd_pr__pfet_01v8__tt.pm3.spice"
.include "C:/pdk/sky130_fd_pr/cells/pfet_01v8/sky130_fd_pr__pfet_01v8__mismatch.corner.spice"
.temp 27
.option gmin=1e-15 reltol=1e-4 abstol=1e-14 vntol=1e-7
Vrail_vdd vdd 0 DC 1.8
XM1 d1 inp tail 0 sky130_fd_pr__nfet_01v8 l=1e-06 w=2e-06 m=2 ad=0 as=0 pd=0 ps=0
XM2 out inn tail 0 sky130_fd_pr__nfet_01v8 l=1e-06 w=2e-06 m=2 ad=0 as=0 pd=0 ps=0
XM3 d1 d1 vdd vdd sky130_fd_pr__pfet_01v8 l=1e-06 w=2e-06 m=2 ad=0 as=0 pd=0 ps=0
XM4 out d1 vdd vdd sky130_fd_pr__pfet_01v8 l=1e-06 w=2e-06 m=2 ad=0 as=0 pd=0 ps=0
Isrc_IT tail 0 DC 2e-05
Cp_CL out 0 1e-12
Ecl_inp inp ecl_inp out 0 -0.5
Vcl_inp ecl_inp 0 PULSE(1.34999955 1.362932013 8.076895793e-09 8.076895793e-09 8.076895793e-09 8.076895793e-09 5.721014961e-07)
Ecl_inn inn ecl_inn out 0 0.5
Vcl_inn ecl_inn 0 PULSE(0.44596855 0.4330360871 8.076895793e-09 8.076895793e-09 8.076895793e-09 8.076895793e-09 5.721014961e-07)
.save v(inp) v(inn)
.control
set noaskquit
set numdgt=8
set wr_singlescale
let sw_tke = 3.230758317e-08
let sw_w = 5.074863297e-08
let sw_k = 5
let sw_rt = 0.0001
let sw_fl0 = 0.00017979681
let sw_u = 5e-09
let sw_j = 0
let sw_m1 = 0
let sw_p1 = 0
let sw_p2 = 0
let sw_fin = 0
let sw_kind = 0
stop when time > 8.305621614e-08
tran 2.24747639e-10 2.86050748e-07 0 2.24747639e-10
while sw_fin = 0
  let sw_j = sw_j + 1
  let hst = v(inp) - v(inn)
  let sw_lo = sw_tke + (sw_j - 1) * sw_w
  let sw_hi = sw_tke + sw_j * sw_w
  let sw_tl = time[length(time) - 1]
  if sw_tl >= sw_hi * (1 - 2 * sw_u)
    let sw_m = maximum(abs(hst - (hst[0])) * (time >= sw_lo) * (time <= sw_hi))
    echo STABWIN $&sw_j $&sw_m
    if sw_j = 1
      let sw_m1 = sw_m
    end
    let sw_fl = sw_fl0 + sw_u * maximum(abs(hst))
    let sw_up = (sw_m * (1 - sw_rt) >= sw_p1 * (1 + sw_rt) + sw_fl)
    let sw_dn = (sw_p1 * (1 - sw_rt) >= sw_m * (1 + sw_rt) + sw_fl)
    let sw_up0 = (sw_p1 * (1 - sw_rt) >= sw_p2 * (1 + sw_rt) + sw_fl)
    let sw_dn0 = (sw_p2 * (1 - sw_rt) >= sw_p1 * (1 + sw_rt) + sw_fl)
    let sw_upf = (sw_m * (1 - sw_rt) >= sw_m1 * (1 + sw_rt) + sw_fl)
    let sw_ab1 = (sw_m * (1 - sw_rt) >= sw_fl)
    let sw_ab0 = (sw_p1 * (1 - sw_rt) >= sw_fl)
    let sw_fl1 = sw_ab1 * (1 - sw_dn)
    let sw_fl0f = sw_ab0 * (1 - sw_dn0)
    let sw_gr = sw_up0 * sw_up * sw_upf
    let sw_lc = sw_fl0f * sw_fl1
    if sw_j >= 3
      if sw_gr >= 1
        let sw_fin = 1
        let sw_kind = 1
      end
      if sw_lc >= 1
        let sw_fin = 1
        let sw_kind = 2
      end
    end
    if sw_fin = 0
      if sw_j >= sw_k
        let sw_fin = 2
      else
        let sw_p2 = sw_p1
        let sw_p1 = sw_m
        let sw_nb = sw_tke + (sw_j + 1) * sw_w
        delete all
        if sw_k >= sw_j + 2
          stop when time > $&sw_nb
        end
        resume
      end
    end
  else
    let sw_fin = 3
  end
end
echo STABEND $&sw_j $&sw_fin $&sw_kind
let hst = v(inp) - v(inn)
wrdata t5ota.free.stab.txt hst
quit
.endc
.end
