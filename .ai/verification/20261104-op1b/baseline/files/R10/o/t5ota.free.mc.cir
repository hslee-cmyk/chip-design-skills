* spice_oracle: t5ota bias=free
.subckt mmv_M1 d g s b params: v0=0 v1=0 v2=0
.param sky130_fd_pr__nfet_01v8__toxe_slope_spectre={v0}
.param sky130_fd_pr__nfet_01v8__vth0_slope_spectre={v1}
.param sky130_fd_pr__nfet_01v8__voff_slope_spectre={v2}
X1 d g s b sky130_fd_pr__nfet_01v8 l=1e-06 w=2e-06 m=2 ad=0 as=0 pd=0 ps=0
.ends
.subckt mmv_M2 d g s b params: v0=0 v1=0 v2=0
.param sky130_fd_pr__nfet_01v8__toxe_slope_spectre={v0}
.param sky130_fd_pr__nfet_01v8__vth0_slope_spectre={v1}
.param sky130_fd_pr__nfet_01v8__voff_slope_spectre={v2}
X1 d g s b sky130_fd_pr__nfet_01v8 l=1e-06 w=2e-06 m=2 ad=0 as=0 pd=0 ps=0
.ends
.subckt mmv_M3 d g s b params: v0=0 v1=0 v2=0 v3=0
.param sky130_fd_pr__pfet_01v8__toxe_slope_spectre={v0}
.param sky130_fd_pr__pfet_01v8__vth0_slope_spectre={v1}
.param sky130_fd_pr__pfet_01v8__voff_slope_spectre={v2}
.param sky130_fd_pr__pfet_01v8__nfactor_slope_spectre={v3}
X1 d g s b sky130_fd_pr__pfet_01v8 l=1e-06 w=2e-06 m=2 ad=0 as=0 pd=0 ps=0
.ends
.subckt mmv_M4 d g s b params: v0=0 v1=0 v2=0 v3=0
.param sky130_fd_pr__pfet_01v8__toxe_slope_spectre={v0}
.param sky130_fd_pr__pfet_01v8__vth0_slope_spectre={v1}
.param sky130_fd_pr__pfet_01v8__voff_slope_spectre={v2}
.param sky130_fd_pr__pfet_01v8__nfactor_slope_spectre={v3}
X1 d g s b sky130_fd_pr__pfet_01v8 l=1e-06 w=2e-06 m=2 ad=0 as=0 pd=0 ps=0
.ends
.param pv_M1_0=0
.param pv_M1_1=0
.param pv_M1_2=0
.param pv_M2_0=0
.param pv_M2_1=0
.param pv_M2_2=0
.param pv_M3_0=0
.param pv_M3_1=0
.param pv_M3_2=0
.param pv_M3_3=0
.param pv_M4_0=0
.param pv_M4_1=0
.param pv_M4_2=0
.param pv_M4_3=0
.include "C:/pdk/sky130_fd_pr/cells/nfet_01v8/sky130_fd_pr__nfet_01v8__tt.pm3.spice"
.include "C:/pdk/sky130_fd_pr/cells/nfet_01v8/sky130_fd_pr__nfet_01v8__mismatch.corner.spice"
.include "C:/pdk/sky130_fd_pr/models/parameters/lod.spice"
.include "C:/pdk/sky130_fd_pr/cells/pfet_01v8/sky130_fd_pr__pfet_01v8__tt.pm3.spice"
.include "C:/pdk/sky130_fd_pr/cells/pfet_01v8/sky130_fd_pr__pfet_01v8__mismatch.corner.spice"
.temp 27
.option gmin=1e-15 reltol=1e-4 abstol=1e-14 vntol=1e-7
Vrail_vdd vdd 0 DC 1.8
XM1 d1 inp tail 0 mmv_M1 v0={pv_M1_0} v1={pv_M1_1} v2={pv_M1_2}
XM2 out inn tail 0 mmv_M2 v0={pv_M2_0} v1={pv_M2_1} v2={pv_M2_2}
XM3 d1 d1 vdd vdd mmv_M3 v0={pv_M3_0} v1={pv_M3_1} v2={pv_M3_2} v3={pv_M3_3}
XM4 out d1 vdd vdd mmv_M4 v0={pv_M4_0} v1={pv_M4_1} v2={pv_M4_2} v3={pv_M4_3}
Isrc_IT tail 0 DC 2e-05
Cp_CL out 0 1e-12
Vdc_inp dcs_inp 0 DC 0.9
Ldc_inp dcs_inp inp 1e+12
Cac_inp inp acs_inp 1
Vac_inp acs_inp 0 DC 0 AC 0.5
Efb_inn fbs_inn 0 out 0 1
Vofs_inn fbs_inn fbd_inn DC 0.004031
Lfb_inn fbd_inn inn 1e+12
Cac_inn inn acs_inn 1
Vac_inn acs_inn 0 DC 0 AC -0.5
.control
set noaskquit
alterparam pv_M1_0 = 0.000000000000e+00
alterparam pv_M1_1 = 0.000000000000e+00
alterparam pv_M1_2 = 0.000000000000e+00
alterparam pv_M2_0 = 0.000000000000e+00
alterparam pv_M2_1 = 0.000000000000e+00
alterparam pv_M2_2 = 0.000000000000e+00
alterparam pv_M3_0 = 0.000000000000e+00
alterparam pv_M3_1 = 0.000000000000e+00
alterparam pv_M3_2 = 0.000000000000e+00
alterparam pv_M3_3 = 0.000000000000e+00
alterparam pv_M4_0 = 0.000000000000e+00
alterparam pv_M4_1 = 0.000000000000e+00
alterparam pv_M4_2 = 0.000000000000e+00
alterparam pv_M4_3 = 0.000000000000e+00
reset
op
echo MCS 0
print v(inn)
print v(inp)
print v(out)
alterparam pv_M1_0 = 8.890469193522e-08
alterparam pv_M1_1 = -9.341224466100e-08
alterparam pv_M1_2 = 4.528471989539e-07
alterparam pv_M2_0 = 7.417558418618e-08
alterparam pv_M2_1 = -3.787754462362e-07
alterparam pv_M2_2 = 2.556863153700e-07
alterparam pv_M3_0 = 9.220672745791e-07
alterparam pv_M3_1 = 6.696873713614e-07
alterparam pv_M3_2 = -4.976159573990e-07
alterparam pv_M3_3 = -8.947881032357e-07
alterparam pv_M4_0 = -4.407215990006e-07
alterparam pv_M4_1 = 2.922188023561e-08
alterparam pv_M4_2 = -1.644045027215e-06
alterparam pv_M4_3 = -1.547090692338e-07
reset
op
echo MCS 1
print v(inn)
print v(inp)
print v(out)
alterparam pv_M1_0 = -8.809920795572e-07
alterparam pv_M1_1 = -5.177912121523e-07
alterparam pv_M1_2 = -3.848492175001e-07
alterparam pv_M2_0 = -2.236579854590e-07
alterparam pv_M2_1 = 2.910667436136e-07
alterparam pv_M2_2 = 7.371682730106e-07
alterparam pv_M3_0 = -9.088773178525e-08
alterparam pv_M3_1 = 9.662355862694e-07
alterparam pv_M3_2 = -4.703636644316e-07
alterparam pv_M3_3 = 2.485551542181e-07
alterparam pv_M4_0 = 6.388498920458e-07
alterparam pv_M4_1 = 6.647673326164e-08
alterparam pv_M4_2 = -5.257333610252e-07
alterparam pv_M4_3 = -6.517582639441e-07
reset
op
echo MCS 2
print v(inn)
print v(inp)
print v(out)
alterparam pv_M1_0 = -3.236610352536e-07
alterparam pv_M1_1 = 1.557014649899e-07
alterparam pv_M1_2 = -7.139078639895e-07
alterparam pv_M2_0 = -1.479094674504e-07
alterparam pv_M2_1 = -1.125890842450e-07
alterparam pv_M2_2 = 3.824355805061e-07
alterparam pv_M3_0 = 1.517869211678e-07
alterparam pv_M3_1 = 2.512864524108e-07
alterparam pv_M3_2 = -4.623266434535e-07
alterparam pv_M3_3 = -9.165067931839e-08
alterparam pv_M4_0 = 5.543543711643e-07
alterparam pv_M4_1 = 1.056015290021e-06
alterparam pv_M4_2 = -8.902937757091e-07
alterparam pv_M4_3 = 1.070505767318e-06
reset
op
echo MCS 3
print v(inn)
print v(inp)
print v(out)
alterparam pv_M1_0 = 9.516776387888e-07
alterparam pv_M1_1 = 5.524705896536e-07
alterparam pv_M1_2 = 1.869983695288e-07
alterparam pv_M2_0 = -2.219769509279e-07
alterparam pv_M2_1 = 1.030976312439e-06
alterparam pv_M2_2 = 1.386111948439e-06
alterparam pv_M3_0 = 1.273948233704e-06
alterparam pv_M3_1 = 9.299187900076e-07
alterparam pv_M3_2 = 2.527061118402e-07
alterparam pv_M3_3 = -8.544102987208e-07
alterparam pv_M4_0 = -3.149547733518e-09
alterparam pv_M4_1 = 4.641978782715e-07
alterparam pv_M4_2 = -9.110091276367e-07
alterparam pv_M4_3 = 2.793934881511e-07
reset
op
echo MCS 4
print v(inn)
print v(inp)
print v(out)
alterparam pv_M1_0 = 3.039595335947e-07
alterparam pv_M1_1 = 4.921765301097e-07
alterparam pv_M1_2 = -8.372978440188e-07
alterparam pv_M2_0 = -4.678943758174e-07
alterparam pv_M2_1 = -3.086063228038e-07
alterparam pv_M2_2 = -8.271748616312e-07
alterparam pv_M3_0 = 1.229918820897e-06
alterparam pv_M3_1 = -3.506618389446e-07
alterparam pv_M3_2 = 2.326166557957e-07
alterparam pv_M3_3 = -1.828384003333e-07
alterparam pv_M4_0 = 1.119684410426e-06
alterparam pv_M4_1 = 9.336362075797e-07
alterparam pv_M4_2 = 4.478479344818e-07
alterparam pv_M4_3 = -1.558116779017e-06
reset
op
echo MCS 5
print v(inn)
print v(inp)
print v(out)
alterparam pv_M1_0 = 3.679004051735e-08
alterparam pv_M1_1 = 4.834391417017e-07
alterparam pv_M1_2 = 7.099080383287e-07
alterparam pv_M2_0 = -4.369262614557e-07
alterparam pv_M2_1 = 1.288356590408e-06
alterparam pv_M2_2 = -9.336856929851e-07
alterparam pv_M3_0 = -4.677709501705e-07
alterparam pv_M3_1 = 6.611801873438e-07
alterparam pv_M3_2 = 3.468685008437e-08
alterparam pv_M3_3 = 1.415905374493e-06
alterparam pv_M4_0 = 1.333031994094e-07
alterparam pv_M4_1 = -4.477358349822e-07
alterparam pv_M4_2 = -2.669777148787e-07
alterparam pv_M4_3 = -7.715568190339e-07
reset
op
echo MCS 6
print v(inn)
print v(inp)
print v(out)
alterparam pv_M1_0 = -9.034563098395e-07
alterparam pv_M1_1 = 4.457682400601e-07
alterparam pv_M1_2 = 4.109462869509e-07
alterparam pv_M2_0 = 9.153913198717e-07
alterparam pv_M2_1 = -5.335868721225e-07
alterparam pv_M2_2 = 1.194379333776e-06
alterparam pv_M3_0 = -2.032137970212e-07
alterparam pv_M3_1 = 1.113274770327e-06
alterparam pv_M3_2 = -3.060258073444e-07
alterparam pv_M3_3 = -5.200652234646e-07
alterparam pv_M4_0 = 1.766249300703e-07
alterparam pv_M4_1 = 7.293474707870e-07
alterparam pv_M4_2 = 1.138509635314e-07
alterparam pv_M4_3 = -4.140314021178e-07
reset
op
echo MCS 7
print v(inn)
print v(inp)
print v(out)
alterparam pv_M1_0 = -9.483855548847e-07
alterparam pv_M1_1 = -9.910244479381e-07
alterparam pv_M1_2 = 3.554504519327e-07
alterparam pv_M2_0 = 6.998327972651e-07
alterparam pv_M2_1 = -1.161738205576e-07
alterparam pv_M2_2 = -7.596906767218e-07
alterparam pv_M3_0 = 6.173340263805e-07
alterparam pv_M3_1 = -9.053752408979e-07
alterparam pv_M3_2 = -5.042152854642e-07
alterparam pv_M3_3 = 4.391259354761e-07
alterparam pv_M4_0 = -1.591090082462e-06
alterparam pv_M4_1 = 2.732045624835e-07
alterparam pv_M4_2 = -4.112821796402e-07
alterparam pv_M4_3 = 7.727241513258e-08
reset
op
echo MCS 8
print v(inn)
print v(inp)
print v(out)
alterparam pv_M1_0 = -5.352906253692e-08
alterparam pv_M1_1 = 1.429164593110e-07
alterparam pv_M1_2 = 4.908536837549e-07
alterparam pv_M2_0 = -5.362483935070e-07
alterparam pv_M2_1 = 1.004786023921e-06
alterparam pv_M2_2 = 5.134258419424e-07
alterparam pv_M3_0 = 5.966090870232e-07
alterparam pv_M3_1 = 8.236832202036e-07
alterparam pv_M3_2 = 5.569089723509e-07
alterparam pv_M3_3 = 5.968537588921e-07
alterparam pv_M4_0 = 5.345275477067e-08
alterparam pv_M4_1 = -1.008881465254e-06
alterparam pv_M4_2 = -9.549130600219e-08
alterparam pv_M4_3 = -5.441290202913e-07
reset
op
echo MCS 9
print v(inn)
print v(inp)
print v(out)
alterparam pv_M1_0 = -1.006030352395e-06
alterparam pv_M1_1 = 1.827537210712e-07
alterparam pv_M1_2 = -4.020251744677e-07
alterparam pv_M2_0 = -7.281817014139e-07
alterparam pv_M2_1 = -7.375131365035e-07
alterparam pv_M2_2 = 1.897995372485e-07
alterparam pv_M3_0 = 2.536193674797e-07
alterparam pv_M3_1 = 9.351186447029e-07
alterparam pv_M3_2 = -9.839156471350e-09
alterparam pv_M3_3 = 7.366919586491e-07
alterparam pv_M4_0 = 9.915509680302e-07
alterparam pv_M4_1 = 8.132899208092e-07
alterparam pv_M4_2 = -1.672522431695e-06
alterparam pv_M4_3 = 8.688105897822e-07
reset
op
echo MCS 10
print v(inn)
print v(inp)
print v(out)
alterparam pv_M1_0 = 2.401476108592e-07
alterparam pv_M1_1 = 2.996515972752e-07
alterparam pv_M1_2 = 2.624974244437e-07
alterparam pv_M2_0 = 2.706501835752e-07
alterparam pv_M2_1 = 2.258599611479e-07
alterparam pv_M2_2 = -2.537900343258e-07
alterparam pv_M3_0 = -1.344659214825e-06
alterparam pv_M3_1 = -7.701434267443e-08
alterparam pv_M3_2 = -5.683242403446e-07
alterparam pv_M3_3 = 7.637908737951e-07
alterparam pv_M4_0 = -2.041887545689e-07
alterparam pv_M4_1 = 5.902599036523e-08
alterparam pv_M4_2 = -6.007621325484e-07
alterparam pv_M4_3 = -3.610646096770e-07
reset
op
echo MCS 11
print v(inn)
print v(inp)
print v(out)
alterparam pv_M1_0 = -8.155106126428e-09
alterparam pv_M1_1 = -1.050318865399e-06
alterparam pv_M1_2 = 2.126164833196e-07
alterparam pv_M2_0 = -7.500440970864e-08
alterparam pv_M2_1 = -8.384305147064e-07
alterparam pv_M2_2 = -1.695806721987e-06
alterparam pv_M3_0 = 3.627826429690e-07
alterparam pv_M3_1 = -2.104236919097e-07
alterparam pv_M3_2 = -3.747725430725e-07
alterparam pv_M3_3 = -1.669865401776e-07
alterparam pv_M4_0 = 1.284442455659e-06
alterparam pv_M4_1 = -3.521460293174e-08
alterparam pv_M4_2 = 6.124906824058e-08
alterparam pv_M4_3 = -1.051519310266e-06
reset
op
echo MCS 12
print v(inn)
print v(inp)
print v(out)
alterparam pv_M1_0 = 1.164844624734e-06
alterparam pv_M1_1 = 6.487619747506e-07
alterparam pv_M1_2 = 7.544368795437e-07
alterparam pv_M2_0 = 3.370971151746e-08
alterparam pv_M2_1 = 6.481728171850e-07
alterparam pv_M2_2 = 2.622990225549e-07
alterparam pv_M3_0 = 4.335901551036e-07
alterparam pv_M3_1 = -1.076166729393e-07
alterparam pv_M3_2 = -1.042196162770e-06
alterparam pv_M3_3 = 7.275098861849e-07
alterparam pv_M4_0 = -1.368223080369e-06
alterparam pv_M4_1 = -1.696608473019e-07
alterparam pv_M4_2 = -1.446192384525e-07
alterparam pv_M4_3 = -7.374134775193e-07
reset
op
echo MCS 13
print v(inn)
print v(inp)
print v(out)
alterparam pv_M1_0 = 4.335435274060e-07
alterparam pv_M1_1 = -1.416544903398e-07
alterparam pv_M1_2 = -3.089125555155e-07
alterparam pv_M2_0 = 3.675836131180e-07
alterparam pv_M2_1 = -3.369922713502e-07
alterparam pv_M2_2 = 9.821571591405e-07
alterparam pv_M3_0 = 2.485162676545e-07
alterparam pv_M3_1 = -3.354040715311e-07
alterparam pv_M3_2 = -1.374802948943e-06
alterparam pv_M3_3 = -9.247211536472e-07
alterparam pv_M4_0 = 7.685054179120e-07
alterparam pv_M4_1 = -3.578247618162e-08
alterparam pv_M4_2 = -2.001996538659e-07
alterparam pv_M4_3 = 1.161954359627e-06
reset
op
echo MCS 14
print v(inn)
print v(inp)
print v(out)
alterparam pv_M1_0 = -9.069699783685e-07
alterparam pv_M1_1 = -4.141226017226e-07
alterparam pv_M1_2 = -3.341699509411e-07
alterparam pv_M2_0 = 4.146030678333e-07
alterparam pv_M2_1 = -4.691902382768e-07
alterparam pv_M2_2 = -4.337519204558e-07
alterparam pv_M3_0 = -1.135012023355e-06
alterparam pv_M3_1 = 5.157279094354e-07
alterparam pv_M3_2 = 5.700266069873e-07
alterparam pv_M3_3 = -3.368492284870e-07
alterparam pv_M4_0 = 1.154987831309e-07
alterparam pv_M4_1 = -9.140388390776e-07
alterparam pv_M4_2 = -3.336222811703e-07
alterparam pv_M4_3 = 9.743584628126e-07
reset
op
echo MCS 15
print v(inn)
print v(inp)
print v(out)
alterparam pv_M1_0 = 9.597612247430e-08
alterparam pv_M1_1 = 1.633673688519e-06
alterparam pv_M1_2 = -5.566293260802e-07
alterparam pv_M2_0 = 4.103230460826e-07
alterparam pv_M2_1 = -1.382434966223e-07
alterparam pv_M2_2 = 4.000936364085e-07
alterparam pv_M3_0 = -5.099201316282e-09
alterparam pv_M3_1 = -3.968269894594e-07
alterparam pv_M3_2 = -6.134976975230e-07
alterparam pv_M3_3 = 2.168015369549e-06
alterparam pv_M4_0 = -5.469121622227e-08
alterparam pv_M4_1 = -1.425994449416e-06
alterparam pv_M4_2 = -4.586298881302e-07
alterparam pv_M4_3 = 4.794464889633e-07
reset
op
echo MCS 16
print v(inn)
print v(inp)
print v(out)
alterparam pv_M1_0 = -3.535593537554e-07
alterparam pv_M1_1 = 9.619807352168e-07
alterparam pv_M1_2 = 7.088026161776e-07
alterparam pv_M2_0 = -1.077196824280e-07
alterparam pv_M2_1 = -3.339070953213e-07
alterparam pv_M2_2 = -7.105016058124e-07
alterparam pv_M3_0 = -4.949510886735e-07
alterparam pv_M3_1 = -1.041669457754e-06
alterparam pv_M3_2 = 8.516367849790e-07
alterparam pv_M3_3 = 1.124795313416e-06
alterparam pv_M4_0 = -8.882237472111e-07
alterparam pv_M4_1 = -8.355760453206e-07
alterparam pv_M4_2 = -1.250526726755e-06
alterparam pv_M4_3 = -6.815478626261e-07
reset
op
echo MCS 17
print v(inn)
print v(inp)
print v(out)
alterparam pv_M1_0 = -2.196511816837e-06
alterparam pv_M1_1 = -8.077131962411e-07
alterparam pv_M1_2 = 9.170576738242e-07
alterparam pv_M2_0 = -2.444273896542e-07
alterparam pv_M2_1 = 6.042823075600e-07
alterparam pv_M2_2 = -3.457533408331e-07
alterparam pv_M3_0 = 1.244979785117e-06
alterparam pv_M3_1 = 1.408683867234e-07
alterparam pv_M3_2 = -2.701164112035e-07
alterparam pv_M3_3 = 1.804836336803e-06
alterparam pv_M4_0 = -2.294362498836e-07
alterparam pv_M4_1 = -8.635353119347e-07
alterparam pv_M4_2 = 1.427719315754e-07
alterparam pv_M4_3 = -2.746051911206e-08
reset
op
echo MCS 18
print v(inn)
print v(inp)
print v(out)
alterparam pv_M1_0 = 7.540053224896e-07
alterparam pv_M1_1 = -6.516935977840e-07
alterparam pv_M1_2 = 5.690207991848e-07
alterparam pv_M2_0 = 6.029842261895e-07
alterparam pv_M2_1 = -4.721262118394e-07
alterparam pv_M2_2 = 1.154309434346e-07
alterparam pv_M3_0 = -5.874303421757e-07
alterparam pv_M3_1 = 1.658736796375e-06
alterparam pv_M3_2 = -4.979018593900e-07
alterparam pv_M3_3 = -3.203720115005e-07
alterparam pv_M4_0 = -7.536612929768e-07
alterparam pv_M4_1 = -2.447447007879e-07
alterparam pv_M4_2 = -4.154978323814e-09
alterparam pv_M4_3 = 5.429089041236e-07
reset
op
echo MCS 19
print v(inn)
print v(inp)
print v(out)
alterparam pv_M1_0 = -4.316792472569e-07
alterparam pv_M1_1 = -1.313620259445e-07
alterparam pv_M1_2 = -1.001609236470e-06
alterparam pv_M2_0 = -5.850617253152e-07
alterparam pv_M2_1 = 1.948650212102e-06
alterparam pv_M2_2 = 7.362701217117e-07
alterparam pv_M3_0 = -5.525502388522e-07
alterparam pv_M3_1 = -9.456826586248e-07
alterparam pv_M3_2 = -6.898412351262e-07
alterparam pv_M3_3 = -1.533775385193e-08
alterparam pv_M4_0 = 2.455625464439e-08
alterparam pv_M4_1 = -5.263424285663e-07
alterparam pv_M4_2 = -9.097455299317e-07
alterparam pv_M4_3 = 1.005773486475e-06
reset
op
echo MCS 20
print v(inn)
print v(inp)
print v(out)
alterparam pv_M1_0 = 3.193898455741e-07
alterparam pv_M1_1 = -2.648595866521e-07
alterparam pv_M1_2 = -1.560310363916e-07
alterparam pv_M2_0 = -3.744345784926e-07
alterparam pv_M2_1 = -2.076097644751e-06
alterparam pv_M2_2 = 8.178526226162e-08
alterparam pv_M3_0 = -7.569892116572e-07
alterparam pv_M3_1 = -7.090048672354e-07
alterparam pv_M3_2 = -4.527338885903e-07
alterparam pv_M3_3 = 5.178155083469e-07
alterparam pv_M4_0 = -8.276902722128e-07
alterparam pv_M4_1 = -1.014190146266e-06
alterparam pv_M4_2 = 4.524437413107e-07
alterparam pv_M4_3 = 5.334193679869e-07
reset
op
echo MCS 21
print v(inn)
print v(inp)
print v(out)
alterparam pv_M1_0 = -6.780685274897e-07
alterparam pv_M1_1 = 3.976752113374e-07
alterparam pv_M1_2 = -2.062152691602e-07
alterparam pv_M2_0 = 2.130457411595e-07
alterparam pv_M2_1 = -8.916335648412e-07
alterparam pv_M2_2 = 5.889453131557e-07
alterparam pv_M3_0 = 8.508325659792e-07
alterparam pv_M3_1 = 4.504788050237e-07
alterparam pv_M3_2 = 3.948059731221e-07
alterparam pv_M3_3 = -2.667401343396e-06
alterparam pv_M4_0 = 1.842930629442e-07
alterparam pv_M4_1 = -1.799255598274e-08
alterparam pv_M4_2 = -1.039768750341e-07
alterparam pv_M4_3 = -4.458859727755e-07
reset
op
echo MCS 22
print v(inn)
print v(inp)
print v(out)
alterparam pv_M1_0 = 3.914894920160e-08
alterparam pv_M1_1 = 2.914110118112e-07
alterparam pv_M1_2 = -1.865263971150e-07
alterparam pv_M2_0 = -3.276196410763e-07
alterparam pv_M2_1 = 8.695672589052e-07
alterparam pv_M2_2 = -7.816125772506e-07
alterparam pv_M3_0 = 7.284297260558e-07
alterparam pv_M3_1 = 1.250252921022e-07
alterparam pv_M3_2 = -5.687299759258e-07
alterparam pv_M3_3 = -2.050481651319e-07
alterparam pv_M4_0 = -6.505337151967e-07
alterparam pv_M4_1 = 4.773426987057e-07
alterparam pv_M4_2 = 2.460036950761e-07
alterparam pv_M4_3 = -3.937143511895e-07
reset
op
echo MCS 23
print v(inn)
print v(inp)
print v(out)
alterparam pv_M1_0 = -7.793860336091e-07
alterparam pv_M1_1 = 2.133454957077e-07
alterparam pv_M1_2 = 6.769738548083e-07
alterparam pv_M2_0 = -8.049445459345e-08
alterparam pv_M2_1 = 2.958198903051e-07
alterparam pv_M2_2 = -2.658913480640e-07
alterparam pv_M3_0 = 4.777864376866e-08
alterparam pv_M3_1 = -2.059681218902e-07
alterparam pv_M3_2 = 2.079191932522e-07
alterparam pv_M3_3 = -1.067570382017e-06
alterparam pv_M4_0 = 4.555114873235e-07
alterparam pv_M4_1 = -1.625868169568e-07
alterparam pv_M4_2 = 2.535741964231e-07
alterparam pv_M4_3 = -2.406355988378e-07
reset
op
echo MCS 24
print v(inn)
print v(inp)
print v(out)
alterparam pv_M1_0 = 2.265295694354e-07
alterparam pv_M1_1 = -7.584164320480e-07
alterparam pv_M1_2 = 8.408591489485e-07
alterparam pv_M2_0 = -1.204587929972e-06
alterparam pv_M2_1 = -7.348528132026e-07
alterparam pv_M2_2 = 1.666410758671e-07
alterparam pv_M3_0 = 1.034385699660e-06
alterparam pv_M3_1 = 1.966649940348e-07
alterparam pv_M3_2 = -1.752977498413e-07
alterparam pv_M3_3 = -1.007690904089e-06
alterparam pv_M4_0 = -1.352530265013e-07
alterparam pv_M4_1 = -1.405516929758e-08
alterparam pv_M4_2 = 1.195412553181e-06
alterparam pv_M4_3 = 4.399089629446e-07
reset
op
echo MCS 25
print v(inn)
print v(inp)
print v(out)
alterparam pv_M1_0 = -1.081231940926e-06
alterparam pv_M1_1 = 1.433149242214e-06
alterparam pv_M1_2 = -2.793141616009e-07
alterparam pv_M2_0 = -6.218719280478e-07
alterparam pv_M2_1 = 1.042857098338e-06
alterparam pv_M2_2 = -3.518263550908e-08
alterparam pv_M3_0 = -2.597928694458e-07
alterparam pv_M3_1 = 1.547050564047e-07
alterparam pv_M3_2 = 5.974265859521e-07
alterparam pv_M3_3 = 7.023947661645e-07
alterparam pv_M4_0 = -9.724149425813e-07
alterparam pv_M4_1 = 1.413139799705e-06
alterparam pv_M4_2 = 6.695322497168e-07
alterparam pv_M4_3 = -2.681356423826e-07
reset
op
echo MCS 26
print v(inn)
print v(inp)
print v(out)
alterparam pv_M1_0 = -5.788799324960e-07
alterparam pv_M1_1 = -6.851952608432e-07
alterparam pv_M1_2 = 8.724172986232e-08
alterparam pv_M2_0 = -4.582167159409e-07
alterparam pv_M2_1 = -5.408475676071e-07
alterparam pv_M2_2 = 5.736434910017e-07
alterparam pv_M3_0 = 2.577880410188e-07
alterparam pv_M3_1 = -2.790040124927e-07
alterparam pv_M3_2 = 5.191914543326e-07
alterparam pv_M3_3 = 9.668826991103e-07
alterparam pv_M4_0 = -7.739257646441e-07
alterparam pv_M4_1 = -4.265917823118e-07
alterparam pv_M4_2 = 6.665342953140e-07
alterparam pv_M4_3 = 5.083677493579e-07
reset
op
echo MCS 27
print v(inn)
print v(inp)
print v(out)
alterparam pv_M1_0 = 1.603002986745e-07
alterparam pv_M1_1 = 8.219559043175e-07
alterparam pv_M1_2 = -7.694818930269e-07
alterparam pv_M2_0 = -1.045908392569e-06
alterparam pv_M2_1 = -6.127132282785e-07
alterparam pv_M2_2 = 8.665176094791e-08
alterparam pv_M3_0 = -5.629183570827e-07
alterparam pv_M3_1 = -3.445152623251e-07
alterparam pv_M3_2 = -6.894291958735e-07
alterparam pv_M3_3 = -4.387096553888e-07
alterparam pv_M4_0 = -7.104918561995e-07
alterparam pv_M4_1 = 2.598378459396e-07
alterparam pv_M4_2 = 5.620728644756e-07
alterparam pv_M4_3 = -3.397265818269e-07
reset
op
echo MCS 28
print v(inn)
print v(inp)
print v(out)
alterparam pv_M1_0 = -1.465590494853e-07
alterparam pv_M1_1 = -4.108520721134e-07
alterparam pv_M1_2 = 3.756513370899e-07
alterparam pv_M2_0 = 6.297212889811e-08
alterparam pv_M2_1 = 1.127239154504e-06
alterparam pv_M2_2 = -7.746157057066e-07
alterparam pv_M3_0 = 2.563279753751e-07
alterparam pv_M3_1 = 3.139493294787e-07
alterparam pv_M3_2 = -2.548696891197e-07
alterparam pv_M3_3 = 4.126209385261e-07
alterparam pv_M4_0 = -1.017189119992e-06
alterparam pv_M4_1 = 1.498219991027e-06
alterparam pv_M4_2 = -9.489687335726e-07
alterparam pv_M4_3 = 6.504019513301e-07
reset
op
echo MCS 29
print v(inn)
print v(inp)
print v(out)
alterparam pv_M1_0 = -7.927534488200e-07
alterparam pv_M1_1 = 8.137971957365e-07
alterparam pv_M1_2 = -2.720763234397e-07
alterparam pv_M2_0 = 1.120219119497e-07
alterparam pv_M2_1 = 3.771973139419e-08
alterparam pv_M2_2 = 7.783365428753e-07
alterparam pv_M3_0 = -2.273683824693e-07
alterparam pv_M3_1 = -2.098115722356e-06
alterparam pv_M3_2 = -5.374427245550e-07
alterparam pv_M3_3 = 1.299042294437e-07
alterparam pv_M4_0 = -3.114580545608e-07
alterparam pv_M4_1 = 5.443455442677e-07
alterparam pv_M4_2 = 7.179446039753e-07
alterparam pv_M4_3 = -1.044904488484e-07
reset
op
echo MCS 30
print v(inn)
print v(inp)
print v(out)
alterparam pv_M1_0 = -1.053338359931e-06
alterparam pv_M1_1 = 9.787525355670e-07
alterparam pv_M1_2 = 7.658344743134e-07
alterparam pv_M2_0 = -2.115600799111e-07
alterparam pv_M2_1 = 1.490785032393e-06
alterparam pv_M2_2 = -2.466922036211e-07
alterparam pv_M3_0 = -8.040650653288e-07
alterparam pv_M3_1 = -1.102191620122e-07
alterparam pv_M3_2 = 7.621435292256e-07
alterparam pv_M3_3 = -6.628796862685e-07
alterparam pv_M4_0 = 1.379724484094e-06
alterparam pv_M4_1 = -6.339397658354e-07
alterparam pv_M4_2 = 6.748784637447e-07
alterparam pv_M4_3 = 3.849930369000e-07
reset
op
echo MCS 31
print v(inn)
print v(inp)
print v(out)
alterparam pv_M1_0 = -1.089347915207e-07
alterparam pv_M1_1 = 7.640521965470e-07
alterparam pv_M1_2 = -1.060517894024e-06
alterparam pv_M2_0 = 9.599482164880e-07
alterparam pv_M2_1 = -4.503140873814e-08
alterparam pv_M2_2 = -3.835596435331e-07
alterparam pv_M3_0 = 5.297460496581e-07
alterparam pv_M3_1 = 7.494617798890e-07
alterparam pv_M3_2 = 5.443275691204e-07
alterparam pv_M3_3 = 1.413862710869e-06
alterparam pv_M4_0 = 7.641887369802e-07
alterparam pv_M4_1 = 9.075762434824e-07
alterparam pv_M4_2 = -3.817414508956e-07
alterparam pv_M4_3 = 7.532368511817e-08
reset
op
echo MCS 32
print v(inn)
print v(inp)
print v(out)
alterparam pv_M1_0 = 3.980888016523e-07
alterparam pv_M1_1 = -1.254565588632e-08
alterparam pv_M1_2 = 2.132883188216e-07
alterparam pv_M2_0 = 3.013015696297e-07
alterparam pv_M2_1 = 5.969705991681e-07
alterparam pv_M2_2 = -7.184833569233e-08
alterparam pv_M3_0 = -2.473453972573e-07
alterparam pv_M3_1 = -5.857076132311e-07
alterparam pv_M3_2 = -6.305499748185e-07
alterparam pv_M3_3 = 8.290482134671e-07
alterparam pv_M4_0 = -5.976571732251e-08
alterparam pv_M4_1 = 5.564537082858e-07
alterparam pv_M4_2 = -9.173747734152e-07
alterparam pv_M4_3 = -1.370491812133e-06
reset
op
echo MCS 33
print v(inn)
print v(inp)
print v(out)
alterparam pv_M1_0 = -7.418195235234e-07
alterparam pv_M1_1 = 8.107877042173e-07
alterparam pv_M1_2 = 7.552448005379e-07
alterparam pv_M2_0 = 2.347867512280e-07
alterparam pv_M2_1 = -5.672199528435e-07
alterparam pv_M2_2 = -9.249143484833e-08
alterparam pv_M3_0 = -2.105484544352e-07
alterparam pv_M3_1 = -2.439329923526e-07
alterparam pv_M3_2 = -1.772058976093e-06
alterparam pv_M3_3 = -6.066455652727e-07
alterparam pv_M4_0 = -1.344272751587e-07
alterparam pv_M4_1 = 1.072276373356e-06
alterparam pv_M4_2 = 1.136625071407e-07
alterparam pv_M4_3 = 9.905776069012e-07
reset
op
echo MCS 34
print v(inn)
print v(inp)
print v(out)
alterparam pv_M1_0 = -2.783928249838e-07
alterparam pv_M1_1 = -1.786778093287e-07
alterparam pv_M1_2 = -2.757307548028e-06
alterparam pv_M2_0 = 3.276240247827e-07
alterparam pv_M2_1 = 3.868550520908e-07
alterparam pv_M2_2 = 1.247165998465e-06
alterparam pv_M3_0 = -3.441921529702e-07
alterparam pv_M3_1 = 6.657704232383e-08
alterparam pv_M3_2 = -4.988836011000e-07
alterparam pv_M3_3 = -8.317393470237e-07
alterparam pv_M4_0 = -5.042434789979e-07
alterparam pv_M4_1 = -2.439507958804e-07
alterparam pv_M4_2 = 9.584394215506e-07
alterparam pv_M4_3 = 1.563839176925e-09
reset
op
echo MCS 35
print v(inn)
print v(inp)
print v(out)
alterparam pv_M1_0 = -5.589995957480e-07
alterparam pv_M1_1 = 1.003227744497e-07
alterparam pv_M1_2 = 1.538461809084e-07
alterparam pv_M2_0 = -4.781682724356e-07
alterparam pv_M2_1 = 8.083882498703e-07
alterparam pv_M2_2 = -1.335264306056e-06
alterparam pv_M3_0 = -1.509988546034e-07
alterparam pv_M3_1 = 4.702727249435e-07
alterparam pv_M3_2 = -9.464147106827e-07
alterparam pv_M3_3 = 2.554449753948e-07
alterparam pv_M4_0 = 9.142134431410e-07
alterparam pv_M4_1 = 3.207940273856e-07
alterparam pv_M4_2 = -1.195123556969e-06
alterparam pv_M4_3 = -5.149116419258e-07
reset
op
echo MCS 36
print v(inn)
print v(inp)
print v(out)
alterparam pv_M1_0 = 8.713700923900e-07
alterparam pv_M1_1 = 2.109548748526e-07
alterparam pv_M1_2 = -6.971322261563e-09
alterparam pv_M2_0 = 3.119759323869e-07
alterparam pv_M2_1 = 5.098586021166e-07
alterparam pv_M2_2 = -5.009605730334e-07
alterparam pv_M3_0 = -2.053438658767e-07
alterparam pv_M3_1 = 1.010552108035e-07
alterparam pv_M3_2 = -3.846361937546e-07
alterparam pv_M3_3 = -9.436450200161e-08
alterparam pv_M4_0 = 9.177339234423e-07
alterparam pv_M4_1 = -6.843519892908e-07
alterparam pv_M4_2 = 1.362356266689e-06
alterparam pv_M4_3 = 1.328897153432e-06
reset
op
echo MCS 37
print v(inn)
print v(inp)
print v(out)
alterparam pv_M1_0 = -1.211584645737e-06
alterparam pv_M1_1 = -9.971808280242e-08
alterparam pv_M1_2 = 2.423195327519e-07
alterparam pv_M2_0 = -5.380171055846e-07
alterparam pv_M2_1 = -5.240230495606e-07
alterparam pv_M2_2 = -1.678782491211e-07
alterparam pv_M3_0 = 5.226778379011e-07
alterparam pv_M3_1 = -3.615676249696e-07
alterparam pv_M3_2 = 1.291667581348e-06
alterparam pv_M3_3 = 2.050425834214e-07
alterparam pv_M4_0 = -7.253167895745e-08
alterparam pv_M4_1 = 1.024781351057e-06
alterparam pv_M4_2 = 4.428476799568e-07
alterparam pv_M4_3 = 2.611251832912e-07
reset
op
echo MCS 38
print v(inn)
print v(inp)
print v(out)
alterparam pv_M1_0 = -2.341516101810e-07
alterparam pv_M1_1 = 1.282681528558e-06
alterparam pv_M1_2 = 5.740445512188e-07
alterparam pv_M2_0 = -1.438335350167e-07
alterparam pv_M2_1 = -1.115248214729e-06
alterparam pv_M2_2 = 2.637165642338e-07
alterparam pv_M3_0 = -8.087463750400e-07
alterparam pv_M3_1 = -1.213357018638e-06
alterparam pv_M3_2 = -1.973899224947e-07
alterparam pv_M3_3 = 1.990301253499e-07
alterparam pv_M4_0 = 9.068511770819e-07
alterparam pv_M4_1 = 1.997236010177e-07
alterparam pv_M4_2 = 5.699418734312e-07
alterparam pv_M4_3 = -8.668299738026e-07
reset
op
echo MCS 39
print v(inn)
print v(inp)
print v(out)
alterparam pv_M1_0 = -1.593265548221e-08
alterparam pv_M1_1 = 8.783066618034e-08
alterparam pv_M1_2 = 6.097001241970e-07
alterparam pv_M2_0 = 8.206728921215e-08
alterparam pv_M2_1 = 5.685696838960e-07
alterparam pv_M2_2 = -3.565227071724e-07
alterparam pv_M3_0 = 2.531123415423e-07
alterparam pv_M3_1 = 2.933548456135e-07
alterparam pv_M3_2 = -8.837248898176e-07
alterparam pv_M3_3 = 1.241245546204e-07
alterparam pv_M4_0 = -2.265305152454e-07
alterparam pv_M4_1 = -1.346393500442e-06
alterparam pv_M4_2 = 6.776958626625e-07
alterparam pv_M4_3 = -2.558727266744e-07
reset
op
echo MCS 40
print v(inn)
print v(inp)
print v(out)
alterparam pv_M1_0 = -6.027307903168e-07
alterparam pv_M1_1 = -2.668032281211e-07
alterparam pv_M1_2 = 9.772237151821e-08
alterparam pv_M2_0 = 1.066253021797e-06
alterparam pv_M2_1 = -1.173324930697e-07
alterparam pv_M2_2 = 3.340425445827e-07
alterparam pv_M3_0 = 9.712672919024e-07
alterparam pv_M3_1 = 3.772771987694e-07
alterparam pv_M3_2 = 7.555889618437e-07
alterparam pv_M3_3 = -3.369433525665e-07
alterparam pv_M4_0 = 5.452142073791e-07
alterparam pv_M4_1 = -4.099522279535e-08
alterparam pv_M4_2 = 7.597234718116e-07
alterparam pv_M4_3 = -7.096237786803e-07
reset
op
echo MCS 41
print v(inn)
print v(inp)
print v(out)
alterparam pv_M1_0 = -5.512305736445e-07
alterparam pv_M1_1 = 8.971286985654e-07
alterparam pv_M1_2 = -1.386523066858e-07
alterparam pv_M2_0 = -2.538235074638e-07
alterparam pv_M2_1 = 5.485198375560e-08
alterparam pv_M2_2 = -4.875483277051e-07
alterparam pv_M3_0 = 9.418247738308e-07
alterparam pv_M3_1 = -8.832913818050e-07
alterparam pv_M3_2 = -1.064888658738e-07
alterparam pv_M3_3 = 2.453326675217e-07
alterparam pv_M4_0 = -7.385523081203e-08
alterparam pv_M4_1 = -5.673029637911e-07
alterparam pv_M4_2 = -6.140438897328e-07
alterparam pv_M4_3 = 3.007992831769e-07
reset
op
echo MCS 42
print v(inn)
print v(inp)
print v(out)
alterparam pv_M1_0 = -7.286597141930e-07
alterparam pv_M1_1 = 4.569625995034e-07
alterparam pv_M1_2 = -1.077735643468e-06
alterparam pv_M2_0 = -3.924323111323e-07
alterparam pv_M2_1 = 2.567223461556e-08
alterparam pv_M2_2 = -8.854051302856e-07
alterparam pv_M3_0 = 4.610413030069e-07
alterparam pv_M3_1 = -1.310892060630e-08
alterparam pv_M3_2 = -7.326147260609e-07
alterparam pv_M3_3 = -1.074016167121e-06
alterparam pv_M4_0 = -1.107038861051e-06
alterparam pv_M4_1 = 3.608644867236e-08
alterparam pv_M4_2 = -8.180024133875e-07
alterparam pv_M4_3 = -9.651156211811e-07
reset
op
echo MCS 43
print v(inn)
print v(inp)
print v(out)
alterparam pv_M1_0 = -1.635014269727e-07
alterparam pv_M1_1 = 1.610436065280e-06
alterparam pv_M1_2 = 1.962506714811e-07
alterparam pv_M2_0 = 5.394650806632e-07
alterparam pv_M2_1 = 1.504145851293e-07
alterparam pv_M2_2 = 5.536519992035e-07
alterparam pv_M3_0 = -9.497070924785e-07
alterparam pv_M3_1 = -3.044179335052e-07
alterparam pv_M3_2 = 1.848029551997e-07
alterparam pv_M3_3 = -1.266910212974e-08
alterparam pv_M4_0 = -1.357597078831e-07
alterparam pv_M4_1 = -4.708454914161e-07
alterparam pv_M4_2 = -1.827044440662e-07
alterparam pv_M4_3 = -5.474405312534e-07
reset
op
echo MCS 44
print v(inn)
print v(inp)
print v(out)
alterparam pv_M1_0 = -1.712494547709e-06
alterparam pv_M1_1 = -8.446450193146e-07
alterparam pv_M1_2 = 3.363374185694e-07
alterparam pv_M2_0 = 1.101020381291e-06
alterparam pv_M2_1 = 1.282394837368e-06
alterparam pv_M2_2 = 6.841381405391e-08
alterparam pv_M3_0 = 6.317176183384e-07
alterparam pv_M3_1 = 6.420373378311e-07
alterparam pv_M3_2 = -4.895011632518e-07
alterparam pv_M3_3 = -1.200624768165e-06
alterparam pv_M4_0 = 2.184063296846e-08
alterparam pv_M4_1 = -1.246064274962e-06
alterparam pv_M4_2 = -2.262243988227e-07
alterparam pv_M4_3 = 4.300037158242e-07
reset
op
echo MCS 45
print v(inn)
print v(inp)
print v(out)
alterparam pv_M1_0 = -1.004140764792e-06
alterparam pv_M1_1 = 2.283628497908e-08
alterparam pv_M1_2 = 8.768252181292e-07
alterparam pv_M2_0 = 2.556279218637e-07
alterparam pv_M2_1 = 3.693372165610e-07
alterparam pv_M2_2 = 6.411622953857e-07
alterparam pv_M3_0 = 1.225389939850e-06
alterparam pv_M3_1 = 1.070722879146e-07
alterparam pv_M3_2 = 8.693883965941e-07
alterparam pv_M3_3 = -4.537448801562e-08
alterparam pv_M4_0 = -3.861996730656e-07
alterparam pv_M4_1 = 2.226120424763e-07
alterparam pv_M4_2 = -4.283743729448e-07
alterparam pv_M4_3 = -4.052635549647e-07
reset
op
echo MCS 46
print v(inn)
print v(inp)
print v(out)
alterparam pv_M1_0 = -4.297375209883e-07
alterparam pv_M1_1 = -1.623110014361e-06
alterparam pv_M1_2 = 7.459939606545e-08
alterparam pv_M2_0 = -8.936665523662e-07
alterparam pv_M2_1 = -7.585072263646e-08
alterparam pv_M2_2 = 1.025282757190e-06
alterparam pv_M3_0 = -3.684028614695e-07
alterparam pv_M3_1 = -3.832583514034e-07
alterparam pv_M3_2 = 9.644295747052e-07
alterparam pv_M3_3 = 3.862965113611e-07
alterparam pv_M4_0 = 6.905089325505e-07
alterparam pv_M4_1 = -2.512288408483e-07
alterparam pv_M4_2 = 5.289747127129e-07
alterparam pv_M4_3 = -4.851944624300e-07
reset
op
echo MCS 47
print v(inn)
print v(inp)
print v(out)
alterparam pv_M1_0 = -4.780054042811e-07
alterparam pv_M1_1 = 4.216083723625e-07
alterparam pv_M1_2 = -4.231137270870e-07
alterparam pv_M2_0 = 5.424347239017e-07
alterparam pv_M2_1 = 1.691176353461e-06
alterparam pv_M2_2 = -1.192289892990e-06
alterparam pv_M3_0 = -5.318888151935e-07
alterparam pv_M3_1 = 7.920629611012e-07
alterparam pv_M3_2 = -1.025857574508e-07
alterparam pv_M3_3 = 8.210145063552e-07
alterparam pv_M4_0 = -7.142232969665e-07
alterparam pv_M4_1 = 2.342957150347e-07
alterparam pv_M4_2 = -1.064593932830e-07
alterparam pv_M4_3 = 9.925709002380e-08
reset
op
echo MCS 48
print v(inn)
print v(inp)
print v(out)
alterparam pv_M1_0 = 2.341343824335e-07
alterparam pv_M1_1 = -8.626747721248e-07
alterparam pv_M1_2 = -7.595298998242e-07
alterparam pv_M2_0 = 9.894149258104e-07
alterparam pv_M2_1 = 2.073334037958e-07
alterparam pv_M2_2 = 7.519821318513e-08
alterparam pv_M3_0 = -3.116553523896e-08
alterparam pv_M3_1 = 2.521136186163e-07
alterparam pv_M3_2 = -8.173707070563e-07
alterparam pv_M3_3 = -7.064190009739e-07
alterparam pv_M4_0 = 9.224266277134e-07
alterparam pv_M4_1 = 1.069677351936e-07
alterparam pv_M4_2 = 6.012535138096e-07
alterparam pv_M4_3 = -4.282691264146e-07
reset
op
echo MCS 49
print v(inn)
print v(inp)
print v(out)
alterparam pv_M1_0 = 9.734918522837e-07
alterparam pv_M1_1 = 2.441487017987e-07
alterparam pv_M1_2 = 3.402921822094e-07
alterparam pv_M2_0 = 3.880102357348e-07
alterparam pv_M2_1 = -5.635706378284e-07
alterparam pv_M2_2 = -1.319263874311e-06
alterparam pv_M3_0 = -7.600002543333e-07
alterparam pv_M3_1 = 1.152953769338e-06
alterparam pv_M3_2 = 9.197224555943e-07
alterparam pv_M3_3 = -2.453104518357e-07
alterparam pv_M4_0 = -2.133173765707e-07
alterparam pv_M4_1 = 7.329910452113e-07
alterparam pv_M4_2 = -1.190837630428e-07
alterparam pv_M4_3 = -9.187154646930e-07
reset
op
echo MCS 50
print v(inn)
print v(inp)
print v(out)
alterparam pv_M1_0 = 8.948741026585e-07
alterparam pv_M1_1 = 3.374162082799e-07
alterparam pv_M1_2 = -1.779320876248e-06
alterparam pv_M2_0 = -2.214588474207e-07
alterparam pv_M2_1 = 1.015901749968e-07
alterparam pv_M2_2 = 3.402928948378e-07
alterparam pv_M3_0 = 1.075871377279e-07
alterparam pv_M3_1 = -4.495373359147e-07
alterparam pv_M3_2 = -8.185400501728e-08
alterparam pv_M3_3 = 2.084553039139e-07
alterparam pv_M4_0 = -1.895075063234e-07
alterparam pv_M4_1 = -2.629735208324e-07
alterparam pv_M4_2 = 8.853570436447e-07
alterparam pv_M4_3 = -6.693527133772e-07
reset
op
echo MCS 51
print v(inn)
print v(inp)
print v(out)
alterparam pv_M1_0 = -2.471079901988e-07
alterparam pv_M1_1 = -1.436324093541e-06
alterparam pv_M1_2 = 3.825235295747e-07
alterparam pv_M2_0 = 5.856714161735e-07
alterparam pv_M2_1 = 3.878387587206e-07
alterparam pv_M2_2 = 6.488924387922e-07
alterparam pv_M3_0 = 3.116267277370e-07
alterparam pv_M3_1 = 2.421949556039e-07
alterparam pv_M3_2 = 3.351311849907e-07
alterparam pv_M3_3 = -1.890156049025e-07
alterparam pv_M4_0 = 8.402746899148e-07
alterparam pv_M4_1 = -2.464776709037e-07
alterparam pv_M4_2 = -1.034038962758e-06
alterparam pv_M4_3 = 6.008877557308e-07
reset
op
echo MCS 52
print v(inn)
print v(inp)
print v(out)
alterparam pv_M1_0 = 1.308644485664e-06
alterparam pv_M1_1 = -6.789293674143e-07
alterparam pv_M1_2 = -7.186406091476e-08
alterparam pv_M2_0 = -4.846806938889e-07
alterparam pv_M2_1 = -2.691129969712e-07
alterparam pv_M2_2 = 3.259265291044e-08
alterparam pv_M3_0 = -8.780911778963e-07
alterparam pv_M3_1 = -1.963307937744e-07
alterparam pv_M3_2 = -1.036595479909e-06
alterparam pv_M3_3 = -4.017976160460e-07
alterparam pv_M4_0 = -8.386778952934e-07
alterparam pv_M4_1 = -7.488690022764e-07
alterparam pv_M4_2 = -1.216160505329e-06
alterparam pv_M4_3 = 8.622138983638e-07
reset
op
echo MCS 53
print v(inn)
print v(inp)
print v(out)
alterparam pv_M1_0 = 3.599591308440e-07
alterparam pv_M1_1 = -1.355851827809e-06
alterparam pv_M1_2 = -4.220208389505e-07
alterparam pv_M2_0 = -4.740716803607e-07
alterparam pv_M2_1 = -4.885712784490e-07
alterparam pv_M2_2 = -1.023101143316e-06
alterparam pv_M3_0 = 5.334312592099e-07
alterparam pv_M3_1 = -2.799179671589e-07
alterparam pv_M3_2 = 3.310312685051e-07
alterparam pv_M3_3 = 3.724725735783e-07
alterparam pv_M4_0 = 9.725867070337e-07
alterparam pv_M4_1 = -1.283308494580e-06
alterparam pv_M4_2 = 1.229377342774e-06
alterparam pv_M4_3 = 8.971878842416e-07
reset
op
echo MCS 54
print v(inn)
print v(inp)
print v(out)
alterparam pv_M1_0 = 4.052188492478e-07
alterparam pv_M1_1 = 1.685454228875e-06
alterparam pv_M1_2 = 1.449417565925e-07
alterparam pv_M2_0 = 5.808733121550e-07
alterparam pv_M2_1 = -5.221375334775e-07
alterparam pv_M2_2 = 8.021118154519e-07
alterparam pv_M3_0 = 1.186708812499e-07
alterparam pv_M3_1 = -3.190466821001e-07
alterparam pv_M3_2 = 1.496902062489e-06
alterparam pv_M3_3 = -2.155259097002e-07
alterparam pv_M4_0 = 6.265904842298e-09
alterparam pv_M4_1 = -1.394979956175e-07
alterparam pv_M4_2 = -5.343400270949e-07
alterparam pv_M4_3 = 3.756663170723e-07
reset
op
echo MCS 55
print v(inn)
print v(inp)
print v(out)
alterparam pv_M1_0 = 5.221344380927e-07
alterparam pv_M1_1 = 2.505792174303e-07
alterparam pv_M1_2 = -1.669180896189e-06
alterparam pv_M2_0 = 7.127615165362e-07
alterparam pv_M2_1 = -2.476559121915e-07
alterparam pv_M2_2 = -8.600705326629e-07
alterparam pv_M3_0 = 4.265840571057e-07
alterparam pv_M3_1 = 3.979946419333e-07
alterparam pv_M3_2 = -7.375644881605e-07
alterparam pv_M3_3 = 1.748276034550e-06
alterparam pv_M4_0 = -8.553351357668e-07
alterparam pv_M4_1 = -1.225417964085e-06
alterparam pv_M4_2 = -8.161224421873e-07
alterparam pv_M4_3 = 1.004657203616e-06
reset
op
echo MCS 56
print v(inn)
print v(inp)
print v(out)
alterparam pv_M1_0 = -1.243494832622e-07
alterparam pv_M1_1 = -2.630838069633e-07
alterparam pv_M1_2 = -4.395214611648e-08
alterparam pv_M2_0 = -4.218697400378e-07
alterparam pv_M2_1 = -4.880899403685e-07
alterparam pv_M2_2 = -4.534078238717e-07
alterparam pv_M3_0 = 5.006001514223e-07
alterparam pv_M3_1 = 7.215712766602e-07
alterparam pv_M3_2 = -7.460631053575e-07
alterparam pv_M3_3 = 1.691597210657e-07
alterparam pv_M4_0 = 5.573466852676e-07
alterparam pv_M4_1 = -7.649141390575e-07
alterparam pv_M4_2 = -3.553682452132e-07
alterparam pv_M4_3 = -7.340222084767e-07
reset
op
echo MCS 57
print v(inn)
print v(inp)
print v(out)
alterparam pv_M1_0 = -9.128950374729e-07
alterparam pv_M1_1 = 7.202792527253e-08
alterparam pv_M1_2 = -5.205241916185e-07
alterparam pv_M2_0 = 4.462756587382e-07
alterparam pv_M2_1 = -2.080444099683e-08
alterparam pv_M2_2 = 2.917716009685e-07
alterparam pv_M3_0 = -2.066752295385e-07
alterparam pv_M3_1 = -4.490109552644e-07
alterparam pv_M3_2 = -6.411558870545e-08
alterparam pv_M3_3 = -3.532797598272e-09
alterparam pv_M4_0 = -4.991152067105e-07
alterparam pv_M4_1 = 3.016485391318e-07
alterparam pv_M4_2 = 5.279222854600e-07
alterparam pv_M4_3 = 1.117813529278e-07
reset
op
echo MCS 58
print v(inn)
print v(inp)
print v(out)
alterparam pv_M1_0 = 1.211621026761e-06
alterparam pv_M1_1 = -4.471312017328e-07
alterparam pv_M1_2 = 3.681172575714e-07
alterparam pv_M2_0 = -2.890191491610e-07
alterparam pv_M2_1 = 1.659081131152e-07
alterparam pv_M2_2 = -5.868628060598e-07
alterparam pv_M3_0 = 7.885113019943e-07
alterparam pv_M3_1 = 1.244655760916e-07
alterparam pv_M3_2 = 8.430441704805e-07
alterparam pv_M3_3 = -8.952647680024e-07
alterparam pv_M4_0 = -3.489679510446e-07
alterparam pv_M4_1 = -6.311393300318e-07
alterparam pv_M4_2 = -3.761397001446e-07
alterparam pv_M4_3 = -4.897490135957e-07
reset
op
echo MCS 59
print v(inn)
print v(inp)
print v(out)
alterparam pv_M1_0 = -8.523531204511e-08
alterparam pv_M1_1 = -1.219557228606e-08
alterparam pv_M1_2 = -2.898067575295e-08
alterparam pv_M2_0 = -3.928146980712e-07
alterparam pv_M2_1 = 1.325296142502e-07
alterparam pv_M2_2 = 6.191536546019e-07
alterparam pv_M3_0 = -6.380051712097e-07
alterparam pv_M3_1 = 6.283527647908e-10
alterparam pv_M3_2 = -5.237602802478e-08
alterparam pv_M3_3 = 3.311767378598e-07
alterparam pv_M4_0 = -4.515483833051e-08
alterparam pv_M4_1 = -1.107668884798e-08
alterparam pv_M4_2 = -7.008105484189e-07
alterparam pv_M4_3 = 1.534693177685e-08
reset
op
echo MCS 60
print v(inn)
print v(inp)
print v(out)
alterparam pv_M1_0 = -6.518707738541e-07
alterparam pv_M1_1 = 3.646579709635e-07
alterparam pv_M1_2 = -7.298680838085e-08
alterparam pv_M2_0 = 2.818415738269e-08
alterparam pv_M2_1 = -6.301667518977e-07
alterparam pv_M2_2 = 5.683424352069e-07
alterparam pv_M3_0 = 4.895398597157e-07
alterparam pv_M3_1 = 6.091894123856e-07
alterparam pv_M3_2 = 1.574999802134e-06
alterparam pv_M3_3 = -3.713681136316e-08
alterparam pv_M4_0 = 8.509343056988e-07
alterparam pv_M4_1 = -8.755948162181e-08
alterparam pv_M4_2 = 2.786617992681e-07
alterparam pv_M4_3 = 2.583325724864e-07
reset
op
echo MCS 61
print v(inn)
print v(inp)
print v(out)
alterparam pv_M1_0 = 1.870946301169e-07
alterparam pv_M1_1 = 4.654574075897e-07
alterparam pv_M1_2 = -2.149154755872e-07
alterparam pv_M2_0 = 2.894349387570e-08
alterparam pv_M2_1 = 3.785210816700e-07
alterparam pv_M2_2 = 1.235919345241e-06
alterparam pv_M3_0 = -5.956361128152e-07
alterparam pv_M3_1 = -1.277128623595e-06
alterparam pv_M3_2 = -3.423001334646e-07
alterparam pv_M3_3 = 6.358900478219e-08
alterparam pv_M4_0 = 1.237274891566e-07
alterparam pv_M4_1 = 6.520782167581e-08
alterparam pv_M4_2 = 8.363589164666e-07
alterparam pv_M4_3 = 6.901714272532e-07
reset
op
echo MCS 62
print v(inn)
print v(inp)
print v(out)
alterparam pv_M1_0 = -3.483766968592e-08
alterparam pv_M1_1 = -3.320199545847e-07
alterparam pv_M1_2 = -2.446652263763e-07
alterparam pv_M2_0 = -2.519450827389e-07
alterparam pv_M2_1 = -1.595229177760e-07
alterparam pv_M2_2 = -1.112031876504e-06
alterparam pv_M3_0 = -3.260050362330e-07
alterparam pv_M3_1 = -3.004355442491e-07
alterparam pv_M3_2 = -1.335586015602e-07
alterparam pv_M3_3 = -1.798172632381e-07
alterparam pv_M4_0 = 4.751808068506e-07
alterparam pv_M4_1 = -3.761407542086e-07
alterparam pv_M4_2 = -3.101212667590e-07
alterparam pv_M4_3 = 3.832085684136e-07
reset
op
echo MCS 63
print v(inn)
print v(inp)
print v(out)
alterparam pv_M1_0 = -1.663927238467e-07
alterparam pv_M1_1 = 1.530566051725e-07
alterparam pv_M1_2 = 4.732918111978e-07
alterparam pv_M2_0 = 2.983774912114e-07
alterparam pv_M2_1 = 1.768915633679e-07
alterparam pv_M2_2 = -1.389051575394e-07
alterparam pv_M3_0 = 4.821719443483e-07
alterparam pv_M3_1 = 1.241325539054e-07
alterparam pv_M3_2 = -3.569848037764e-07
alterparam pv_M3_3 = -1.066381987922e-07
alterparam pv_M4_0 = -8.613475430673e-07
alterparam pv_M4_1 = -6.799227498097e-07
alterparam pv_M4_2 = -1.331417041157e-06
alterparam pv_M4_3 = -4.807840906758e-07
reset
op
echo MCS 64
print v(inn)
print v(inp)
print v(out)
alterparam pv_M1_0 = 9.443732242178e-07
alterparam pv_M1_1 = -3.934970324139e-07
alterparam pv_M1_2 = 5.568754522345e-07
alterparam pv_M2_0 = -2.439415315048e-09
alterparam pv_M2_1 = -4.953628233603e-07
alterparam pv_M2_2 = 9.463065202700e-07
alterparam pv_M3_0 = 4.116817035725e-07
alterparam pv_M3_1 = -1.238710058996e-06
alterparam pv_M3_2 = 7.363825562804e-07
alterparam pv_M3_3 = -7.599923546340e-07
alterparam pv_M4_0 = -1.258041580962e-07
alterparam pv_M4_1 = 4.724275310744e-07
alterparam pv_M4_2 = -2.120282032199e-07
alterparam pv_M4_3 = 7.912129294953e-07
reset
op
echo MCS 65
print v(inn)
print v(inp)
print v(out)
alterparam pv_M1_0 = 5.382947673304e-07
alterparam pv_M1_1 = -1.115019437263e-06
alterparam pv_M1_2 = -3.340613956785e-07
alterparam pv_M2_0 = 1.994562495554e-07
alterparam pv_M2_1 = -4.065854666958e-07
alterparam pv_M2_2 = -1.529305841320e-07
alterparam pv_M3_0 = 5.655333343338e-07
alterparam pv_M3_1 = 2.239982101090e-07
alterparam pv_M3_2 = -6.509759626474e-07
alterparam pv_M3_3 = 1.234653478083e-07
alterparam pv_M4_0 = -4.329400109008e-07
alterparam pv_M4_1 = -8.592707576568e-07
alterparam pv_M4_2 = -7.990701546560e-07
alterparam pv_M4_3 = 2.029082061831e-07
reset
op
echo MCS 66
print v(inn)
print v(inp)
print v(out)
alterparam pv_M1_0 = -1.987939215233e-08
alterparam pv_M1_1 = 3.840868665770e-09
alterparam pv_M1_2 = -8.104921904080e-07
alterparam pv_M2_0 = -1.300578320568e-07
alterparam pv_M2_1 = -7.333882486664e-07
alterparam pv_M2_2 = -6.550593617644e-07
alterparam pv_M3_0 = -1.167622494819e-07
alterparam pv_M3_1 = -9.782047691574e-07
alterparam pv_M3_2 = 4.732434224744e-07
alterparam pv_M3_3 = 1.758491728152e-06
alterparam pv_M4_0 = 3.244370307981e-07
alterparam pv_M4_1 = -7.374438817045e-07
alterparam pv_M4_2 = -1.917571160161e-07
alterparam pv_M4_3 = -1.099860717622e-06
reset
op
echo MCS 67
print v(inn)
print v(inp)
print v(out)
alterparam pv_M1_0 = -2.670151038989e-07
alterparam pv_M1_1 = 3.587251240315e-07
alterparam pv_M1_2 = 4.167579648980e-07
alterparam pv_M2_0 = -7.295522976934e-07
alterparam pv_M2_1 = 2.115279201429e-07
alterparam pv_M2_2 = 8.177039562999e-07
alterparam pv_M3_0 = 1.241037161427e-06
alterparam pv_M3_1 = -4.955368137771e-07
alterparam pv_M3_2 = -6.110816888428e-07
alterparam pv_M3_3 = 3.847783005919e-08
alterparam pv_M4_0 = -2.070472416949e-06
alterparam pv_M4_1 = -3.754977432544e-07
alterparam pv_M4_2 = -1.916082383324e-07
alterparam pv_M4_3 = -3.248038342717e-07
reset
op
echo MCS 68
print v(inn)
print v(inp)
print v(out)
alterparam pv_M1_0 = -1.119967500174e-06
alterparam pv_M1_1 = -1.736308534035e-07
alterparam pv_M1_2 = -5.491452215693e-07
alterparam pv_M2_0 = 5.356214072697e-07
alterparam pv_M2_1 = -6.494597717487e-07
alterparam pv_M2_2 = -1.996481558892e-07
alterparam pv_M3_0 = -1.647190575146e-07
alterparam pv_M3_1 = 4.013336008263e-07
alterparam pv_M3_2 = -1.800226407173e-06
alterparam pv_M3_3 = -2.408582019426e-07
alterparam pv_M4_0 = 5.371290231434e-07
alterparam pv_M4_1 = -2.557522052183e-07
alterparam pv_M4_2 = -1.079707483377e-06
alterparam pv_M4_3 = 2.309397825573e-07
reset
op
echo MCS 69
print v(inn)
print v(inp)
print v(out)
alterparam pv_M1_0 = 2.380735945415e-07
alterparam pv_M1_1 = -1.912648832921e-07
alterparam pv_M1_2 = -8.200994094170e-07
alterparam pv_M2_0 = -5.237364180585e-07
alterparam pv_M2_1 = -2.218593551104e-07
alterparam pv_M2_2 = -6.190952194583e-07
alterparam pv_M3_0 = -1.357771131208e-06
alterparam pv_M3_1 = -5.439679122015e-07
alterparam pv_M3_2 = -4.365955476213e-08
alterparam pv_M3_3 = -3.585456120508e-07
alterparam pv_M4_0 = -5.343806702828e-08
alterparam pv_M4_1 = 5.915512422504e-08
alterparam pv_M4_2 = 6.339746161533e-07
alterparam pv_M4_3 = 1.558338982235e-06
reset
op
echo MCS 70
print v(inn)
print v(inp)
print v(out)
alterparam pv_M1_0 = 5.174457801822e-07
alterparam pv_M1_1 = -9.930102382785e-07
alterparam pv_M1_2 = -1.878743789477e-06
alterparam pv_M2_0 = -6.679484003166e-08
alterparam pv_M2_1 = 5.047924666920e-08
alterparam pv_M2_2 = -8.215684934353e-07
alterparam pv_M3_0 = 1.923557689163e-07
alterparam pv_M3_1 = -5.423081833424e-07
alterparam pv_M3_2 = 2.847304986285e-07
alterparam pv_M3_3 = -2.301761075078e-07
alterparam pv_M4_0 = 2.810484931694e-07
alterparam pv_M4_1 = -1.232625142684e-06
alterparam pv_M4_2 = -3.100429007084e-07
alterparam pv_M4_3 = -1.050732438340e-07
reset
op
echo MCS 71
print v(inn)
print v(inp)
print v(out)
alterparam pv_M1_0 = -1.007538580459e-06
alterparam pv_M1_1 = 1.331014146879e-06
alterparam pv_M1_2 = -3.823845467781e-07
alterparam pv_M2_0 = 9.828584352394e-07
alterparam pv_M2_1 = -4.697607976586e-07
alterparam pv_M2_2 = -1.626141635179e-07
alterparam pv_M3_0 = 8.371450700299e-07
alterparam pv_M3_1 = 2.148380224257e-07
alterparam pv_M3_2 = 1.358029334463e-07
alterparam pv_M3_3 = 1.880504156175e-07
alterparam pv_M4_0 = -9.660194984613e-07
alterparam pv_M4_1 = -2.754559028443e-07
alterparam pv_M4_2 = -6.763092076961e-07
alterparam pv_M4_3 = 1.395925322503e-07
reset
op
echo MCS 72
print v(inn)
print v(inp)
print v(out)
alterparam pv_M1_0 = -3.846647669611e-07
alterparam pv_M1_1 = -3.115450358559e-08
alterparam pv_M1_2 = -5.465409561710e-08
alterparam pv_M2_0 = -2.571774580070e-08
alterparam pv_M2_1 = -2.456992553036e-08
alterparam pv_M2_2 = -4.613009829215e-07
alterparam pv_M3_0 = -7.452925241276e-07
alterparam pv_M3_1 = -4.697708514680e-07
alterparam pv_M3_2 = 7.576920269705e-07
alterparam pv_M3_3 = 2.645723506123e-07
alterparam pv_M4_0 = 4.150401157284e-07
alterparam pv_M4_1 = 9.757846714387e-07
alterparam pv_M4_2 = -8.339836107879e-07
alterparam pv_M4_3 = 3.605908153123e-07
reset
op
echo MCS 73
print v(inn)
print v(inp)
print v(out)
alterparam pv_M1_0 = -7.601921900669e-07
alterparam pv_M1_1 = -2.364088478305e-07
alterparam pv_M1_2 = 3.424092765438e-07
alterparam pv_M2_0 = 1.141514485569e-06
alterparam pv_M2_1 = -5.530741348306e-07
alterparam pv_M2_2 = -6.703107374729e-08
alterparam pv_M3_0 = 8.175828847340e-07
alterparam pv_M3_1 = -1.053453423870e-06
alterparam pv_M3_2 = 2.560524975442e-07
alterparam pv_M3_3 = -2.179855706380e-07
alterparam pv_M4_0 = -6.234524932646e-07
alterparam pv_M4_1 = 1.036836493263e-07
alterparam pv_M4_2 = 4.206761112151e-07
alterparam pv_M4_3 = -6.449519270595e-07
reset
op
echo MCS 74
print v(inn)
print v(inp)
print v(out)
alterparam pv_M1_0 = 2.686933515254e-07
alterparam pv_M1_1 = 1.225910953146e-07
alterparam pv_M1_2 = -8.780946096422e-07
alterparam pv_M2_0 = 1.098428772196e-06
alterparam pv_M2_1 = 7.706775686631e-07
alterparam pv_M2_2 = -6.080600347561e-07
alterparam pv_M3_0 = -4.148106752324e-07
alterparam pv_M3_1 = 5.450239300875e-07
alterparam pv_M3_2 = -3.503353811368e-07
alterparam pv_M3_3 = -1.300877501228e-06
alterparam pv_M4_0 = 7.416716543438e-07
alterparam pv_M4_1 = 6.209403727565e-09
alterparam pv_M4_2 = 1.348471151532e-06
alterparam pv_M4_3 = 2.527674268440e-07
reset
op
echo MCS 75
print v(inn)
print v(inp)
print v(out)
alterparam pv_M1_0 = 1.350520843984e-07
alterparam pv_M1_1 = 2.032578782918e-06
alterparam pv_M1_2 = -1.215285657868e-07
alterparam pv_M2_0 = -6.730353817847e-07
alterparam pv_M2_1 = 1.620674455877e-07
alterparam pv_M2_2 = 8.030999936921e-07
alterparam pv_M3_0 = -8.238643548513e-07
alterparam pv_M3_1 = -6.422404179050e-07
alterparam pv_M3_2 = 3.180404362844e-07
alterparam pv_M3_3 = -2.260864608255e-06
alterparam pv_M4_0 = -7.726404887171e-07
alterparam pv_M4_1 = 5.624921890207e-07
alterparam pv_M4_2 = -4.148877735047e-07
alterparam pv_M4_3 = -1.150097252611e-06
reset
op
echo MCS 76
print v(inn)
print v(inp)
print v(out)
alterparam pv_M1_0 = 1.361581241802e-06
alterparam pv_M1_1 = -9.973989748100e-07
alterparam pv_M1_2 = -3.700753272948e-07
alterparam pv_M2_0 = -2.635609707103e-07
alterparam pv_M2_1 = 5.879196479928e-08
alterparam pv_M2_2 = -2.612796339500e-07
alterparam pv_M3_0 = -5.725095609411e-08
alterparam pv_M3_1 = 4.065480674604e-08
alterparam pv_M3_2 = -6.128949054977e-08
alterparam pv_M3_3 = 6.595456526150e-08
alterparam pv_M4_0 = -1.682154485794e-06
alterparam pv_M4_1 = 3.118798387334e-07
alterparam pv_M4_2 = -9.931008550253e-07
alterparam pv_M4_3 = -1.532049733417e-06
reset
op
echo MCS 77
print v(inn)
print v(inp)
print v(out)
alterparam pv_M1_0 = 9.767604718578e-07
alterparam pv_M1_1 = -9.089965712406e-07
alterparam pv_M1_2 = 1.271866645462e-07
alterparam pv_M2_0 = -5.462834663871e-07
alterparam pv_M2_1 = -4.797480620480e-07
alterparam pv_M2_2 = 3.419955666177e-07
alterparam pv_M3_0 = -7.412069768533e-07
alterparam pv_M3_1 = 2.635205073197e-07
alterparam pv_M3_2 = 2.691902314981e-07
alterparam pv_M3_3 = 8.233890162828e-07
alterparam pv_M4_0 = -2.377386481380e-07
alterparam pv_M4_1 = 7.400454084233e-07
alterparam pv_M4_2 = 1.216714895489e-06
alterparam pv_M4_3 = 1.121953799367e-06
reset
op
echo MCS 78
print v(inn)
print v(inp)
print v(out)
alterparam pv_M1_0 = 4.144189904444e-07
alterparam pv_M1_1 = 3.176083753399e-07
alterparam pv_M1_2 = 2.014868925415e-06
alterparam pv_M2_0 = 1.578386757267e-06
alterparam pv_M2_1 = -5.420802801681e-07
alterparam pv_M2_2 = 6.530902127176e-07
alterparam pv_M3_0 = 4.256494549900e-07
alterparam pv_M3_1 = 5.110081208460e-08
alterparam pv_M3_2 = 1.084081656415e-07
alterparam pv_M3_3 = 3.449161607839e-07
alterparam pv_M4_0 = 6.628125357225e-07
alterparam pv_M4_1 = 1.546936526931e-07
alterparam pv_M4_2 = 2.402704397698e-07
alterparam pv_M4_3 = 9.843918564934e-07
reset
op
echo MCS 79
print v(inn)
print v(inp)
print v(out)
alterparam pv_M1_0 = 2.246621386477e-07
alterparam pv_M1_1 = 3.853890927184e-07
alterparam pv_M1_2 = 7.001984162263e-07
alterparam pv_M2_0 = 1.154890929852e-06
alterparam pv_M2_1 = 8.676489618310e-07
alterparam pv_M2_2 = 2.667312511089e-07
alterparam pv_M3_0 = 1.469477167418e-07
alterparam pv_M3_1 = -8.652183873829e-07
alterparam pv_M3_2 = 2.065194054662e-07
alterparam pv_M3_3 = -7.333897704993e-07
alterparam pv_M4_0 = -7.241052332983e-07
alterparam pv_M4_1 = 4.599792738358e-07
alterparam pv_M4_2 = -7.111880853906e-08
alterparam pv_M4_3 = 3.339025367830e-07
reset
op
echo MCS 80
print v(inn)
print v(inp)
print v(out)
alterparam pv_M1_0 = -4.433298718518e-07
alterparam pv_M1_1 = 8.493794992749e-07
alterparam pv_M1_2 = 1.016622834637e-07
alterparam pv_M2_0 = 8.398507542528e-07
alterparam pv_M2_1 = 4.761943373332e-07
alterparam pv_M2_2 = 1.168487157777e-07
alterparam pv_M3_0 = -3.383699773800e-07
alterparam pv_M3_1 = 2.227922181427e-08
alterparam pv_M3_2 = 5.854918291812e-07
alterparam pv_M3_3 = 4.933185147675e-07
alterparam pv_M4_0 = -8.454060152680e-07
alterparam pv_M4_1 = 7.252667348380e-07
alterparam pv_M4_2 = -1.512557559667e-07
alterparam pv_M4_3 = 5.764785055772e-07
reset
op
echo MCS 81
print v(inn)
print v(inp)
print v(out)
alterparam pv_M1_0 = -4.931986794414e-07
alterparam pv_M1_1 = 4.510317993177e-07
alterparam pv_M1_2 = -5.632755221846e-07
alterparam pv_M2_0 = 9.146909285905e-08
alterparam pv_M2_1 = -2.107388973272e-07
alterparam pv_M2_2 = -2.019302985471e-07
alterparam pv_M3_0 = -4.006376820769e-07
alterparam pv_M3_1 = -1.085968204072e-07
alterparam pv_M3_2 = -1.230814592986e-06
alterparam pv_M3_3 = 6.198495875902e-07
alterparam pv_M4_0 = 6.800151071063e-07
alterparam pv_M4_1 = -3.130884080223e-07
alterparam pv_M4_2 = -9.756338523530e-07
alterparam pv_M4_3 = -4.572925101461e-07
reset
op
echo MCS 82
print v(inn)
print v(inp)
print v(out)
alterparam pv_M1_0 = 6.700645184789e-07
alterparam pv_M1_1 = 4.423099806313e-07
alterparam pv_M1_2 = -2.123820396792e-07
alterparam pv_M2_0 = 6.344690816251e-07
alterparam pv_M2_1 = -7.364381052780e-07
alterparam pv_M2_2 = -4.331993041157e-07
alterparam pv_M3_0 = 3.355980025302e-07
alterparam pv_M3_1 = -6.782096584020e-08
alterparam pv_M3_2 = -4.166454875220e-07
alterparam pv_M3_3 = -1.776342553451e-06
alterparam pv_M4_0 = 4.746216218473e-07
alterparam pv_M4_1 = 2.289058894712e-07
alterparam pv_M4_2 = -1.232432197600e-06
alterparam pv_M4_3 = 4.244943635678e-07
reset
op
echo MCS 83
print v(inn)
print v(inp)
print v(out)
alterparam pv_M1_0 = -1.015671122152e-08
alterparam pv_M1_1 = 1.971659619120e-07
alterparam pv_M1_2 = 6.683525259013e-07
alterparam pv_M2_0 = -5.231789770901e-07
alterparam pv_M2_1 = 5.045660947005e-07
alterparam pv_M2_2 = 4.835579082101e-07
alterparam pv_M3_0 = 5.384729432112e-07
alterparam pv_M3_1 = 1.156795424562e-06
alterparam pv_M3_2 = 4.657958743157e-07
alterparam pv_M3_3 = -3.970812650084e-07
alterparam pv_M4_0 = 1.271649818660e-06
alterparam pv_M4_1 = -7.829882098901e-07
alterparam pv_M4_2 = -3.271949913856e-07
alterparam pv_M4_3 = -6.819830729002e-07
reset
op
echo MCS 84
print v(inn)
print v(inp)
print v(out)
alterparam pv_M1_0 = -7.266285819619e-08
alterparam pv_M1_1 = 7.652445938889e-07
alterparam pv_M1_2 = 9.176732506106e-07
alterparam pv_M2_0 = 3.277563079130e-07
alterparam pv_M2_1 = -4.309045534528e-07
alterparam pv_M2_2 = -3.914688791568e-07
alterparam pv_M3_0 = -4.265240786161e-07
alterparam pv_M3_1 = 6.737601078615e-07
alterparam pv_M3_2 = -6.410201045513e-07
alterparam pv_M3_3 = 6.113123918579e-07
alterparam pv_M4_0 = -2.304748907199e-08
alterparam pv_M4_1 = 1.216584800412e-07
alterparam pv_M4_2 = 1.068946320501e-06
alterparam pv_M4_3 = -3.361119046686e-07
reset
op
echo MCS 85
print v(inn)
print v(inp)
print v(out)
alterparam pv_M1_0 = 1.175019558827e-06
alterparam pv_M1_1 = -9.966335332045e-07
alterparam pv_M1_2 = -5.831960008590e-07
alterparam pv_M2_0 = -1.116091264500e-06
alterparam pv_M2_1 = -5.280545342789e-07
alterparam pv_M2_2 = 4.121598835706e-07
alterparam pv_M3_0 = 5.216532245142e-07
alterparam pv_M3_1 = 2.169228973870e-07
alterparam pv_M3_2 = 1.888625372940e-07
alterparam pv_M3_3 = -8.296674617790e-07
alterparam pv_M4_0 = -9.382117865563e-07
alterparam pv_M4_1 = 2.148826850289e-07
alterparam pv_M4_2 = 9.530434533836e-07
alterparam pv_M4_3 = -2.574821583196e-07
reset
op
echo MCS 86
print v(inn)
print v(inp)
print v(out)
alterparam pv_M1_0 = -8.970071072304e-07
alterparam pv_M1_1 = -1.084193023278e-06
alterparam pv_M1_2 = -4.812934430298e-07
alterparam pv_M2_0 = 1.116906147837e-06
alterparam pv_M2_1 = -1.468940357097e-07
alterparam pv_M2_2 = -7.339367982830e-07
alterparam pv_M3_0 = -4.309609668442e-07
alterparam pv_M3_1 = -3.419179282171e-07
alterparam pv_M3_2 = 1.878170470774e-07
alterparam pv_M3_3 = -4.667021100179e-07
alterparam pv_M4_0 = -6.292823080963e-07
alterparam pv_M4_1 = -1.329480847486e-07
alterparam pv_M4_2 = 3.313999646629e-07
alterparam pv_M4_3 = 5.070265107100e-07
reset
op
echo MCS 87
print v(inn)
print v(inp)
print v(out)
alterparam pv_M1_0 = 3.892849219628e-07
alterparam pv_M1_1 = -3.234991813421e-07
alterparam pv_M1_2 = -1.198600454080e-06
alterparam pv_M2_0 = -5.646361795152e-07
alterparam pv_M2_1 = 2.008758795944e-07
alterparam pv_M2_2 = -9.430225540137e-07
alterparam pv_M3_0 = 1.786287656292e-07
alterparam pv_M3_1 = -4.171759944003e-07
alterparam pv_M3_2 = -4.116520792844e-07
alterparam pv_M3_3 = 7.916109969584e-07
alterparam pv_M4_0 = 1.546673258539e-07
alterparam pv_M4_1 = 9.689174317683e-07
alterparam pv_M4_2 = -6.641521570382e-07
alterparam pv_M4_3 = 7.995547647227e-07
reset
op
echo MCS 88
print v(inn)
print v(inp)
print v(out)
alterparam pv_M1_0 = 6.428169227260e-07
alterparam pv_M1_1 = -2.117786775315e-06
alterparam pv_M1_2 = -6.241681887241e-08
alterparam pv_M2_0 = 1.090517337661e-06
alterparam pv_M2_1 = 5.501696503761e-07
alterparam pv_M2_2 = -3.120611824903e-07
alterparam pv_M3_0 = -1.646076638391e-07
alterparam pv_M3_1 = -9.213946294297e-07
alterparam pv_M3_2 = 1.458708186294e-07
alterparam pv_M3_3 = -1.267964138469e-06
alterparam pv_M4_0 = -7.179302836570e-07
alterparam pv_M4_1 = 7.913687085474e-07
alterparam pv_M4_2 = -1.454168197964e-08
alterparam pv_M4_3 = -2.569810236227e-07
reset
op
echo MCS 89
print v(inn)
print v(inp)
print v(out)
alterparam pv_M1_0 = -7.489047331276e-08
alterparam pv_M1_1 = 1.938811849524e-06
alterparam pv_M1_2 = 7.319884480680e-07
alterparam pv_M2_0 = -5.484612757454e-07
alterparam pv_M2_1 = 1.178570051113e-06
alterparam pv_M2_2 = -6.278750273018e-08
alterparam pv_M3_0 = 5.230588597381e-07
alterparam pv_M3_1 = -4.148103712018e-07
alterparam pv_M3_2 = -6.631643291161e-07
alterparam pv_M3_3 = 5.670378806933e-07
alterparam pv_M4_0 = -5.436850344415e-07
alterparam pv_M4_1 = -5.524753377326e-07
alterparam pv_M4_2 = 6.348647213173e-07
alterparam pv_M4_3 = -8.217068911039e-07
reset
op
echo MCS 90
print v(inn)
print v(inp)
print v(out)
alterparam pv_M1_0 = -1.003562714648e-06
alterparam pv_M1_1 = 3.854116597746e-07
alterparam pv_M1_2 = -1.385845587143e-06
alterparam pv_M2_0 = -5.315503094218e-07
alterparam pv_M2_1 = -2.585508453101e-07
alterparam pv_M2_2 = -9.512756953621e-07
alterparam pv_M3_0 = -7.901144149193e-07
alterparam pv_M3_1 = 4.708432631049e-07
alterparam pv_M3_2 = 2.067955462337e-07
alterparam pv_M3_3 = -6.687189922811e-07
alterparam pv_M4_0 = 3.744028342838e-07
alterparam pv_M4_1 = 1.074292088149e-06
alterparam pv_M4_2 = -9.068063297187e-07
alterparam pv_M4_3 = 4.331438791980e-08
reset
op
echo MCS 91
print v(inn)
print v(inp)
print v(out)
alterparam pv_M1_0 = 1.397703571882e-06
alterparam pv_M1_1 = 4.321553019354e-07
alterparam pv_M1_2 = 5.751501369679e-07
alterparam pv_M2_0 = -1.415293105833e-07
alterparam pv_M2_1 = -5.642455831060e-07
alterparam pv_M2_2 = 8.084858788645e-07
alterparam pv_M3_0 = 4.622533410478e-07
alterparam pv_M3_1 = -3.643239366814e-08
alterparam pv_M3_2 = -3.290420465509e-07
alterparam pv_M3_3 = -1.235828360666e-06
alterparam pv_M4_0 = 1.102423518393e-07
alterparam pv_M4_1 = -4.891147864563e-07
alterparam pv_M4_2 = -9.323504730063e-08
alterparam pv_M4_3 = 4.744512442148e-07
reset
op
echo MCS 92
print v(inn)
print v(inp)
print v(out)
alterparam pv_M1_0 = 5.798294737943e-07
alterparam pv_M1_1 = 5.084104608921e-07
alterparam pv_M1_2 = 1.594571281314e-06
alterparam pv_M2_0 = 8.238632128694e-07
alterparam pv_M2_1 = -5.275569373842e-07
alterparam pv_M2_2 = -5.786268391983e-07
alterparam pv_M3_0 = 1.646251164981e-06
alterparam pv_M3_1 = -4.690424246673e-07
alterparam pv_M3_2 = -3.120839999519e-08
alterparam pv_M3_3 = 1.233801693167e-06
alterparam pv_M4_0 = 1.212911486733e-06
alterparam pv_M4_1 = -3.863067829091e-08
alterparam pv_M4_2 = 1.710795936173e-07
alterparam pv_M4_3 = -1.156196875482e-06
reset
op
echo MCS 93
print v(inn)
print v(inp)
print v(out)
alterparam pv_M1_0 = -6.422995258212e-07
alterparam pv_M1_1 = -2.582772077909e-07
alterparam pv_M1_2 = -4.002344228102e-09
alterparam pv_M2_0 = -2.286221011164e-07
alterparam pv_M2_1 = 1.076881071061e-07
alterparam pv_M2_2 = 1.550474109593e-06
alterparam pv_M3_0 = 3.283385715237e-07
alterparam pv_M3_1 = 2.182889458624e-07
alterparam pv_M3_2 = 1.291428635681e-09
alterparam pv_M3_3 = -1.215570332329e-07
alterparam pv_M4_0 = 8.718234876357e-07
alterparam pv_M4_1 = -7.009276795876e-07
alterparam pv_M4_2 = -8.879813375240e-08
alterparam pv_M4_3 = -7.748315107696e-07
reset
op
echo MCS 94
print v(inn)
print v(inp)
print v(out)
alterparam pv_M1_0 = 6.161000307279e-08
alterparam pv_M1_1 = 8.418129015384e-08
alterparam pv_M1_2 = 6.508963940131e-07
alterparam pv_M2_0 = 8.468746536462e-07
alterparam pv_M2_1 = 4.688572864395e-07
alterparam pv_M2_2 = 1.147110542744e-06
alterparam pv_M3_0 = 1.123241432721e-06
alterparam pv_M3_1 = 2.229922668299e-07
alterparam pv_M3_2 = 2.639960982971e-07
alterparam pv_M3_3 = -1.369157914490e-06
alterparam pv_M4_0 = 2.264461416918e-07
alterparam pv_M4_1 = -3.600272273800e-09
alterparam pv_M4_2 = -1.193946414324e-06
alterparam pv_M4_3 = -3.050359884245e-07
reset
op
echo MCS 95
print v(inn)
print v(inp)
print v(out)
alterparam pv_M1_0 = 6.770009793751e-07
alterparam pv_M1_1 = -8.759457264984e-07
alterparam pv_M1_2 = 9.142545362916e-07
alterparam pv_M2_0 = 3.357338179824e-07
alterparam pv_M2_1 = -1.614947673535e-07
alterparam pv_M2_2 = -1.006405899120e-07
alterparam pv_M3_0 = 5.868470833054e-07
alterparam pv_M3_1 = -1.012148601594e-06
alterparam pv_M3_2 = 1.443036606489e-06
alterparam pv_M3_3 = -5.751744652834e-07
alterparam pv_M4_0 = -5.411369699092e-07
alterparam pv_M4_1 = 8.632134704894e-07
alterparam pv_M4_2 = 5.586513635791e-07
alterparam pv_M4_3 = 9.371934557223e-07
reset
op
echo MCS 96
print v(inn)
print v(inp)
print v(out)
alterparam pv_M1_0 = 7.396203103224e-07
alterparam pv_M1_1 = 2.661521136642e-07
alterparam pv_M1_2 = -9.025398854762e-07
alterparam pv_M2_0 = -3.343483068040e-07
alterparam pv_M2_1 = 1.403178203784e-07
alterparam pv_M2_2 = -1.214991209072e-08
alterparam pv_M3_0 = -1.451536652808e-06
alterparam pv_M3_1 = 7.385061119075e-07
alterparam pv_M3_2 = 1.224102574060e-06
alterparam pv_M3_3 = 1.035271643298e-06
alterparam pv_M4_0 = -7.197354441778e-07
alterparam pv_M4_1 = 3.082750663252e-07
alterparam pv_M4_2 = -1.503661215790e-06
alterparam pv_M4_3 = 1.195023288524e-06
reset
op
echo MCS 97
print v(inn)
print v(inp)
print v(out)
alterparam pv_M1_0 = -1.371700117572e-06
alterparam pv_M1_1 = 2.902735302286e-07
alterparam pv_M1_2 = 8.220679814951e-07
alterparam pv_M2_0 = 9.131023526347e-07
alterparam pv_M2_1 = 2.432238834817e-07
alterparam pv_M2_2 = -1.008086817322e-06
alterparam pv_M3_0 = -7.154208935354e-08
alterparam pv_M3_1 = -1.897298126138e-07
alterparam pv_M3_2 = 2.604692592743e-07
alterparam pv_M3_3 = 6.984418833873e-07
alterparam pv_M4_0 = 4.681335973029e-07
alterparam pv_M4_1 = 1.500209455006e-06
alterparam pv_M4_2 = 4.674335423661e-07
alterparam pv_M4_3 = -2.749354967671e-07
reset
op
echo MCS 98
print v(inn)
print v(inp)
print v(out)
alterparam pv_M1_0 = 1.152569594528e-06
alterparam pv_M1_1 = -2.224049275959e-07
alterparam pv_M1_2 = 1.993075999649e-07
alterparam pv_M2_0 = 1.278292976205e-07
alterparam pv_M2_1 = -1.621559444291e-06
alterparam pv_M2_2 = 1.957412662341e-07
alterparam pv_M3_0 = 2.046649538666e-07
alterparam pv_M3_1 = -1.482838664201e-07
alterparam pv_M3_2 = -9.990497829911e-08
alterparam pv_M3_3 = -9.082104200490e-07
alterparam pv_M4_0 = 5.831036487843e-08
alterparam pv_M4_1 = 1.062728803053e-06
alterparam pv_M4_2 = -1.253485136386e-07
alterparam pv_M4_3 = -3.691986595076e-07
reset
op
echo MCS 99
print v(inn)
print v(inp)
print v(out)
alterparam pv_M1_0 = -4.297292226432e-07
alterparam pv_M1_1 = 1.426296538129e-06
alterparam pv_M1_2 = -9.583018611439e-07
alterparam pv_M2_0 = 5.974697102459e-07
alterparam pv_M2_1 = 7.878004292345e-08
alterparam pv_M2_2 = 1.358278886983e-06
alterparam pv_M3_0 = 9.272046710425e-07
alterparam pv_M3_1 = -6.245027505875e-08
alterparam pv_M3_2 = -1.089982926617e-06
alterparam pv_M3_3 = 1.010908027832e-06
alterparam pv_M4_0 = 1.030992564657e-06
alterparam pv_M4_1 = -7.812836928705e-07
alterparam pv_M4_2 = 5.269596594411e-07
alterparam pv_M4_3 = -5.662274568458e-07
reset
op
echo MCS 100
print v(inn)
print v(inp)
print v(out)
alterparam pv_M1_0 = -5.488494291217e-07
alterparam pv_M1_1 = -1.137956431938e-06
alterparam pv_M1_2 = 6.596636125691e-07
alterparam pv_M2_0 = 1.917167486673e-07
alterparam pv_M2_1 = 3.496641128788e-07
alterparam pv_M2_2 = 1.027054877263e-06
alterparam pv_M3_0 = 4.727890146036e-07
alterparam pv_M3_1 = 4.133482893879e-07
alterparam pv_M3_2 = 5.298166408540e-07
alterparam pv_M3_3 = -7.527659700979e-07
alterparam pv_M4_0 = -2.437053040126e-08
alterparam pv_M4_1 = -8.529557251750e-07
alterparam pv_M4_2 = -6.363346629897e-07
alterparam pv_M4_3 = -6.492407083124e-08
reset
op
echo MCS 101
print v(inn)
print v(inp)
print v(out)
alterparam pv_M1_0 = 7.508679356694e-07
alterparam pv_M1_1 = 1.455377086361e-06
alterparam pv_M1_2 = -7.673474443786e-07
alterparam pv_M2_0 = 1.225631127930e-07
alterparam pv_M2_1 = -5.014125029826e-08
alterparam pv_M2_2 = 3.728118838983e-07
alterparam pv_M3_0 = 4.118259772107e-07
alterparam pv_M3_1 = 2.562704629192e-07
alterparam pv_M3_2 = -6.838970917692e-07
alterparam pv_M3_3 = 2.790776679376e-07
alterparam pv_M4_0 = 6.309702698512e-07
alterparam pv_M4_1 = -3.630221390219e-07
alterparam pv_M4_2 = 1.398773831776e-06
alterparam pv_M4_3 = -1.661087039448e-07
reset
op
echo MCS 102
print v(inn)
print v(inp)
print v(out)
alterparam pv_M1_0 = -4.482068441848e-07
alterparam pv_M1_1 = 2.095716278598e-07
alterparam pv_M1_2 = -1.821432709975e-07
alterparam pv_M2_0 = -9.667371679079e-07
alterparam pv_M2_1 = -1.849564112444e-08
alterparam pv_M2_2 = 1.128332016715e-06
alterparam pv_M3_0 = 1.416004181207e-06
alterparam pv_M3_1 = -4.009588619269e-07
alterparam pv_M3_2 = 6.401258110711e-07
alterparam pv_M3_3 = 9.371247623357e-08
alterparam pv_M4_0 = 2.007381609153e-07
alterparam pv_M4_1 = 8.961667791441e-07
alterparam pv_M4_2 = 6.025055557092e-07
alterparam pv_M4_3 = 1.091210124605e-07
reset
op
echo MCS 103
print v(inn)
print v(inp)
print v(out)
alterparam pv_M1_0 = -6.567213823965e-07
alterparam pv_M1_1 = -7.947744749950e-07
alterparam pv_M1_2 = -4.526764001605e-08
alterparam pv_M2_0 = 2.288291783342e-07
alterparam pv_M2_1 = 3.557962571189e-07
alterparam pv_M2_2 = 5.529358324520e-07
alterparam pv_M3_0 = 6.926712873226e-07
alterparam pv_M3_1 = -1.699231827987e-06
alterparam pv_M3_2 = 6.388287858827e-07
alterparam pv_M3_3 = -7.406574257589e-07
alterparam pv_M4_0 = 7.877654439175e-07
alterparam pv_M4_1 = 2.380434871360e-07
alterparam pv_M4_2 = 4.458731231010e-07
alterparam pv_M4_3 = -3.824922646735e-07
reset
op
echo MCS 104
print v(inn)
print v(inp)
print v(out)
alterparam pv_M1_0 = 1.998646660493e-07
alterparam pv_M1_1 = -1.320318676804e-06
alterparam pv_M1_2 = 7.744563097434e-07
alterparam pv_M2_0 = -2.339383155721e-07
alterparam pv_M2_1 = -1.830756233511e-06
alterparam pv_M2_2 = 7.505822189104e-07
alterparam pv_M3_0 = 1.185658072631e-06
alterparam pv_M3_1 = -6.195171222470e-07
alterparam pv_M3_2 = 8.575153838560e-07
alterparam pv_M3_3 = -5.301571637132e-07
alterparam pv_M4_0 = -1.602672107125e-06
alterparam pv_M4_1 = -2.530681954985e-07
alterparam pv_M4_2 = 2.306132967963e-07
alterparam pv_M4_3 = 9.443490921817e-08
reset
op
echo MCS 105
print v(inn)
print v(inp)
print v(out)
alterparam pv_M1_0 = 7.325481260468e-08
alterparam pv_M1_1 = 2.096026128224e-07
alterparam pv_M1_2 = 1.531279782521e-07
alterparam pv_M2_0 = -1.527621493711e-07
alterparam pv_M2_1 = -4.252408470360e-07
alterparam pv_M2_2 = -1.879495817454e-07
alterparam pv_M3_0 = -2.486700562876e-07
alterparam pv_M3_1 = -2.141986412056e-07
alterparam pv_M3_2 = -7.799058505949e-07
alterparam pv_M3_3 = -3.836721687258e-07
alterparam pv_M4_0 = 5.814269568108e-08
alterparam pv_M4_1 = 2.187922097969e-07
alterparam pv_M4_2 = -4.527530298270e-08
alterparam pv_M4_3 = -1.298671707879e-07
reset
op
echo MCS 106
print v(inn)
print v(inp)
print v(out)
alterparam pv_M1_0 = 3.779131298072e-07
alterparam pv_M1_1 = 5.759163129848e-07
alterparam pv_M1_2 = 4.808890939776e-07
alterparam pv_M2_0 = -1.237372580767e-06
alterparam pv_M2_1 = -3.220200282128e-07
alterparam pv_M2_2 = 4.989731436681e-07
alterparam pv_M3_0 = 3.644409425775e-07
alterparam pv_M3_1 = 4.806986861051e-07
alterparam pv_M3_2 = 2.222800829968e-07
alterparam pv_M3_3 = -6.035416609067e-07
alterparam pv_M4_0 = 8.644836712563e-07
alterparam pv_M4_1 = -9.613745125820e-07
alterparam pv_M4_2 = 6.970360196303e-07
alterparam pv_M4_3 = -1.157896634305e-08
reset
op
echo MCS 107
print v(inn)
print v(inp)
print v(out)
alterparam pv_M1_0 = -1.041323788336e-06
alterparam pv_M1_1 = -2.801265742982e-07
alterparam pv_M1_2 = 8.511810228274e-07
alterparam pv_M2_0 = -4.160628107986e-07
alterparam pv_M2_1 = -8.560251641081e-07
alterparam pv_M2_2 = -2.042055679866e-07
alterparam pv_M3_0 = -5.784663507036e-07
alterparam pv_M3_1 = -8.843077258643e-07
alterparam pv_M3_2 = 3.093859116248e-07
alterparam pv_M3_3 = 5.643930512577e-07
alterparam pv_M4_0 = -3.901330264895e-07
alterparam pv_M4_1 = 3.702573200940e-07
alterparam pv_M4_2 = -2.736694267520e-07
alterparam pv_M4_3 = -7.050853690690e-08
reset
op
echo MCS 108
print v(inn)
print v(inp)
print v(out)
alterparam pv_M1_0 = 8.725868162761e-08
alterparam pv_M1_1 = 1.055910918353e-06
alterparam pv_M1_2 = 3.588983154145e-07
alterparam pv_M2_0 = -7.064796542209e-07
alterparam pv_M2_1 = 3.647463505331e-07
alterparam pv_M2_2 = -1.564037258033e-07
alterparam pv_M3_0 = -3.297666076155e-07
alterparam pv_M3_1 = -5.938009504808e-07
alterparam pv_M3_2 = -1.856880972939e-08
alterparam pv_M3_3 = -4.252005276047e-08
alterparam pv_M4_0 = -2.843858772430e-07
alterparam pv_M4_1 = -9.836897206415e-07
alterparam pv_M4_2 = -1.207153105083e-06
alterparam pv_M4_3 = 9.049870219028e-08
reset
op
echo MCS 109
print v(inn)
print v(inp)
print v(out)
alterparam pv_M1_0 = 1.260097896086e-07
alterparam pv_M1_1 = 1.543705099030e-06
alterparam pv_M1_2 = -1.263338254678e-07
alterparam pv_M2_0 = 7.222558928495e-07
alterparam pv_M2_1 = 8.451366569513e-07
alterparam pv_M2_2 = -4.318071684221e-08
alterparam pv_M3_0 = 5.430651033264e-08
alterparam pv_M3_1 = -3.039454214797e-07
alterparam pv_M3_2 = 1.255227115631e-06
alterparam pv_M3_3 = -1.066622617255e-06
alterparam pv_M4_0 = -2.803406054965e-08
alterparam pv_M4_1 = 9.787227551269e-07
alterparam pv_M4_2 = -7.614130298177e-08
alterparam pv_M4_3 = -4.037137777272e-07
reset
op
echo MCS 110
print v(inn)
print v(inp)
print v(out)
alterparam pv_M1_0 = 1.646728918046e-07
alterparam pv_M1_1 = 3.726367973719e-07
alterparam pv_M1_2 = 4.012428453410e-07
alterparam pv_M2_0 = 1.991518978667e-07
alterparam pv_M2_1 = 5.303945172461e-07
alterparam pv_M2_2 = 6.687116296719e-07
alterparam pv_M3_0 = -7.826844133228e-07
alterparam pv_M3_1 = -2.679169789688e-07
alterparam pv_M3_2 = 6.149646343272e-07
alterparam pv_M3_3 = 3.455065327337e-07
alterparam pv_M4_0 = 1.658873274802e-07
alterparam pv_M4_1 = 4.755143848216e-07
alterparam pv_M4_2 = 6.732743625391e-07
alterparam pv_M4_3 = -6.067308940433e-07
reset
op
echo MCS 111
print v(inn)
print v(inp)
print v(out)
alterparam pv_M1_0 = -8.675807139658e-07
alterparam pv_M1_1 = -8.157759841794e-07
alterparam pv_M1_2 = 1.314281080728e-06
alterparam pv_M2_0 = -7.455964228476e-07
alterparam pv_M2_1 = -1.658781451306e-07
alterparam pv_M2_2 = -1.311529630458e-07
alterparam pv_M3_0 = 7.290696346306e-07
alterparam pv_M3_1 = -1.229178636913e-06
alterparam pv_M3_2 = -2.776681825022e-08
alterparam pv_M3_3 = 8.587022350506e-07
alterparam pv_M4_0 = 7.883531821882e-07
alterparam pv_M4_1 = 2.894272868870e-07
alterparam pv_M4_2 = -1.845117981630e-07
alterparam pv_M4_3 = 1.242869884295e-06
reset
op
echo MCS 112
print v(inn)
print v(inp)
print v(out)
alterparam pv_M1_0 = -1.182245186302e-06
alterparam pv_M1_1 = 6.936613403465e-07
alterparam pv_M1_2 = 3.593360311106e-07
alterparam pv_M2_0 = 4.179260474747e-07
alterparam pv_M2_1 = 1.879552263628e-07
alterparam pv_M2_2 = 1.450842736246e-07
alterparam pv_M3_0 = 6.581665036788e-07
alterparam pv_M3_1 = -8.153257890667e-07
alterparam pv_M3_2 = -8.814453337962e-07
alterparam pv_M3_3 = 1.148717843373e-07
alterparam pv_M4_0 = 3.687617844276e-08
alterparam pv_M4_1 = 1.157252106005e-07
alterparam pv_M4_2 = 1.124605947659e-06
alterparam pv_M4_3 = -4.096335723068e-07
reset
op
echo MCS 113
print v(inn)
print v(inp)
print v(out)
alterparam pv_M1_0 = 5.312625908353e-07
alterparam pv_M1_1 = 2.718455783263e-07
alterparam pv_M1_2 = 1.673412322796e-06
alterparam pv_M2_0 = -9.914956897641e-07
alterparam pv_M2_1 = -3.860853359485e-07
alterparam pv_M2_2 = -3.229993306431e-07
alterparam pv_M3_0 = 9.338072634434e-07
alterparam pv_M3_1 = -5.797699814588e-07
alterparam pv_M3_2 = 1.172342737779e-06
alterparam pv_M3_3 = 1.130033225288e-06
alterparam pv_M4_0 = 6.120805753280e-07
alterparam pv_M4_1 = 3.092715639730e-07
alterparam pv_M4_2 = -1.100384150132e-06
alterparam pv_M4_3 = 1.287991515035e-07
reset
op
echo MCS 114
print v(inn)
print v(inp)
print v(out)
alterparam pv_M1_0 = -1.011637631545e-06
alterparam pv_M1_1 = -2.564155791315e-07
alterparam pv_M1_2 = 1.436139057778e-07
alterparam pv_M2_0 = -2.184050465836e-07
alterparam pv_M2_1 = 6.723211030544e-07
alterparam pv_M2_2 = -9.134132960293e-08
alterparam pv_M3_0 = -1.095012989179e-06
alterparam pv_M3_1 = -7.495736529721e-07
alterparam pv_M3_2 = -9.007892612619e-07
alterparam pv_M3_3 = -2.237500658917e-07
alterparam pv_M4_0 = 8.821757125043e-07
alterparam pv_M4_1 = 3.576164602028e-07
alterparam pv_M4_2 = 2.400694496311e-07
alterparam pv_M4_3 = -9.089018995093e-07
reset
op
echo MCS 115
print v(inn)
print v(inp)
print v(out)
alterparam pv_M1_0 = 1.675251826191e-06
alterparam pv_M1_1 = -1.998507364120e-08
alterparam pv_M1_2 = 1.709015338374e-06
alterparam pv_M2_0 = -6.133595868271e-07
alterparam pv_M2_1 = -4.015280970599e-07
alterparam pv_M2_2 = 1.838238268557e-06
alterparam pv_M3_0 = -7.601355324664e-07
alterparam pv_M3_1 = 2.960697251335e-07
alterparam pv_M3_2 = -2.391472430165e-07
alterparam pv_M3_3 = -5.751693812963e-07
alterparam pv_M4_0 = 1.528114037452e-06
alterparam pv_M4_1 = -7.100278752282e-07
alterparam pv_M4_2 = 6.345823753036e-07
alterparam pv_M4_3 = 7.808669262305e-07
reset
op
echo MCS 116
print v(inn)
print v(inp)
print v(out)
alterparam pv_M1_0 = -7.154516703811e-07
alterparam pv_M1_1 = -1.341540868602e-06
alterparam pv_M1_2 = -1.259102546206e-06
alterparam pv_M2_0 = -5.653908922115e-07
alterparam pv_M2_1 = 1.574476972056e-07
alterparam pv_M2_2 = 2.371934051749e-07
alterparam pv_M3_0 = -1.336761145531e-07
alterparam pv_M3_1 = -7.446300011017e-08
alterparam pv_M3_2 = 6.887554923073e-07
alterparam pv_M3_3 = 5.431661800175e-07
alterparam pv_M4_0 = 2.678196810007e-07
alterparam pv_M4_1 = -4.362616329825e-07
alterparam pv_M4_2 = 5.498269848616e-07
alterparam pv_M4_3 = 1.281345917215e-07
reset
op
echo MCS 117
print v(inn)
print v(inp)
print v(out)
alterparam pv_M1_0 = -5.287993038025e-07
alterparam pv_M1_1 = -4.079269866973e-07
alterparam pv_M1_2 = 8.687851616806e-07
alterparam pv_M2_0 = 1.304882099622e-06
alterparam pv_M2_1 = -3.745733646774e-07
alterparam pv_M2_2 = -1.469416083696e-06
alterparam pv_M3_0 = 4.153995779871e-07
alterparam pv_M3_1 = -6.387032696022e-07
alterparam pv_M3_2 = 5.179544167269e-07
alterparam pv_M3_3 = -2.658419404993e-07
alterparam pv_M4_0 = 1.576564204406e-06
alterparam pv_M4_1 = 7.936885087741e-08
alterparam pv_M4_2 = 6.384118531565e-07
alterparam pv_M4_3 = -8.591727328969e-07
reset
op
echo MCS 118
print v(inn)
print v(inp)
print v(out)
alterparam pv_M1_0 = -1.993540094256e-06
alterparam pv_M1_1 = 9.569355152791e-08
alterparam pv_M1_2 = 1.852358774316e-07
alterparam pv_M2_0 = 5.093287568252e-07
alterparam pv_M2_1 = -3.916038343781e-07
alterparam pv_M2_2 = -9.134677668315e-07
alterparam pv_M3_0 = -1.131721133520e-06
alterparam pv_M3_1 = 3.911296917394e-07
alterparam pv_M3_2 = 5.022515304562e-07
alterparam pv_M3_3 = -6.192546526896e-07
alterparam pv_M4_0 = -3.733768607042e-07
alterparam pv_M4_1 = -5.149048641751e-07
alterparam pv_M4_2 = -1.340114062900e-06
alterparam pv_M4_3 = 1.407959971635e-07
reset
op
echo MCS 119
print v(inn)
print v(inp)
print v(out)
alterparam pv_M1_0 = 5.982237330510e-07
alterparam pv_M1_1 = -1.579320950343e-07
alterparam pv_M1_2 = -1.005839812669e-06
alterparam pv_M2_0 = -1.402347486453e-07
alterparam pv_M2_1 = 9.647925369446e-07
alterparam pv_M2_2 = 1.506071019542e-06
alterparam pv_M3_0 = 1.902804119695e-07
alterparam pv_M3_1 = -5.578655513471e-07
alterparam pv_M3_2 = -1.404013872633e-06
alterparam pv_M3_3 = -1.093141895515e-06
alterparam pv_M4_0 = -6.285298950009e-08
alterparam pv_M4_1 = 1.596402666536e-07
alterparam pv_M4_2 = 1.814718308758e-07
alterparam pv_M4_3 = -1.859531491166e-07
reset
op
echo MCS 120
print v(inn)
print v(inp)
print v(out)
alterparam pv_M1_0 = -1.091222815153e-06
alterparam pv_M1_1 = -1.114722678153e-06
alterparam pv_M1_2 = 1.041740570476e-07
alterparam pv_M2_0 = -5.830575408970e-07
alterparam pv_M2_1 = 9.226580597589e-07
alterparam pv_M2_2 = -1.031607101163e-06
alterparam pv_M3_0 = 1.192958382353e-06
alterparam pv_M3_1 = -4.712839700867e-07
alterparam pv_M3_2 = 1.578184563512e-07
alterparam pv_M3_3 = 1.577993135135e-07
alterparam pv_M4_0 = -2.432500712846e-07
alterparam pv_M4_1 = -1.423747373239e-06
alterparam pv_M4_2 = -3.411050489492e-07
alterparam pv_M4_3 = 1.076541928702e-06
reset
op
echo MCS 121
print v(inn)
print v(inp)
print v(out)
alterparam pv_M1_0 = -9.056576100940e-07
alterparam pv_M1_1 = -1.302567869744e-06
alterparam pv_M1_2 = -1.547669339245e-07
alterparam pv_M2_0 = -2.916016904247e-07
alterparam pv_M2_1 = -9.141771741301e-07
alterparam pv_M2_2 = -5.321492699475e-07
alterparam pv_M3_0 = -3.401742818319e-07
alterparam pv_M3_1 = -2.919463328950e-07
alterparam pv_M3_2 = 1.150984735913e-07
alterparam pv_M3_3 = 4.996863777327e-07
alterparam pv_M4_0 = 2.737032902746e-07
alterparam pv_M4_1 = 2.416528481443e-07
alterparam pv_M4_2 = 1.188040477218e-06
alterparam pv_M4_3 = 7.744963378567e-07
reset
op
echo MCS 122
print v(inn)
print v(inp)
print v(out)
alterparam pv_M1_0 = -2.059689025047e-06
alterparam pv_M1_1 = -2.567942022973e-07
alterparam pv_M1_2 = -1.114789330595e-06
alterparam pv_M2_0 = -4.872930669543e-07
alterparam pv_M2_1 = 5.452315586263e-07
alterparam pv_M2_2 = -1.422600726146e-07
alterparam pv_M3_0 = -3.029169530681e-07
alterparam pv_M3_1 = 9.312394991684e-07
alterparam pv_M3_2 = -1.063331579913e-06
alterparam pv_M3_3 = -6.633676314224e-08
alterparam pv_M4_0 = 3.880311103242e-07
alterparam pv_M4_1 = 1.706581326953e-08
alterparam pv_M4_2 = -8.225597901925e-07
alterparam pv_M4_3 = -1.595767705327e-08
reset
op
echo MCS 123
print v(inn)
print v(inp)
print v(out)
alterparam pv_M1_0 = 5.709973350946e-07
alterparam pv_M1_1 = 2.526138786516e-07
alterparam pv_M1_2 = 2.246417614690e-07
alterparam pv_M2_0 = 2.173985865467e-07
alterparam pv_M2_1 = 9.559496203967e-08
alterparam pv_M2_2 = -8.777039305865e-07
alterparam pv_M3_0 = -2.185682520843e-07
alterparam pv_M3_1 = 3.046482543174e-07
alterparam pv_M3_2 = -2.202290577192e-06
alterparam pv_M3_3 = 5.354056742160e-07
alterparam pv_M4_0 = 2.385951253071e-07
alterparam pv_M4_1 = -7.666308256123e-07
alterparam pv_M4_2 = -5.277492168098e-07
alterparam pv_M4_3 = -1.441375629163e-07
reset
op
echo MCS 124
print v(inn)
print v(inp)
print v(out)
alterparam pv_M1_0 = 2.923426632113e-07
alterparam pv_M1_1 = -2.644767783512e-07
alterparam pv_M1_2 = 8.251958113068e-07
alterparam pv_M2_0 = 2.921239220574e-07
alterparam pv_M2_1 = -5.561899749857e-07
alterparam pv_M2_2 = -3.331759301003e-07
alterparam pv_M3_0 = 1.609230950337e-07
alterparam pv_M3_1 = 5.150382169862e-07
alterparam pv_M3_2 = 4.808435540450e-07
alterparam pv_M3_3 = -6.900920360805e-08
alterparam pv_M4_0 = 1.057089618709e-07
alterparam pv_M4_1 = -1.774911658073e-08
alterparam pv_M4_2 = 5.812346502217e-07
alterparam pv_M4_3 = -6.973801853882e-07
reset
op
echo MCS 125
print v(inn)
print v(inp)
print v(out)
alterparam pv_M1_0 = 4.262741560593e-07
alterparam pv_M1_1 = -1.309846767386e-06
alterparam pv_M1_2 = 3.189284639671e-07
alterparam pv_M2_0 = 1.811698193806e-07
alterparam pv_M2_1 = -2.645653533583e-10
alterparam pv_M2_2 = -1.507982519099e-06
alterparam pv_M3_0 = 1.107841214214e-06
alterparam pv_M3_1 = 6.352726129648e-07
alterparam pv_M3_2 = 1.799468889460e-08
alterparam pv_M3_3 = 3.243550641403e-07
alterparam pv_M4_0 = -6.642434892241e-07
alterparam pv_M4_1 = 3.622318206234e-07
alterparam pv_M4_2 = 1.103148200971e-06
alterparam pv_M4_3 = -8.330323093032e-07
reset
op
echo MCS 126
print v(inn)
print v(inp)
print v(out)
alterparam pv_M1_0 = 1.904067076366e-06
alterparam pv_M1_1 = -3.089554306512e-07
alterparam pv_M1_2 = 5.850657177644e-07
alterparam pv_M2_0 = -5.841485358376e-07
alterparam pv_M2_1 = 2.760584703687e-07
alterparam pv_M2_2 = -9.008111807755e-07
alterparam pv_M3_0 = -4.659791357774e-07
alterparam pv_M3_1 = -1.616285446929e-07
alterparam pv_M3_2 = -4.637359079718e-07
alterparam pv_M3_3 = -1.707167668422e-07
alterparam pv_M4_0 = 6.901028880731e-07
alterparam pv_M4_1 = -9.030356196394e-07
alterparam pv_M4_2 = -8.455251775984e-07
alterparam pv_M4_3 = 3.327591825881e-08
reset
op
echo MCS 127
print v(inn)
print v(inp)
print v(out)
alterparam pv_M1_0 = -3.989423423613e-07
alterparam pv_M1_1 = -7.097577641680e-07
alterparam pv_M1_2 = 9.336128110421e-08
alterparam pv_M2_0 = -3.990676307104e-07
alterparam pv_M2_1 = 2.376870122313e-07
alterparam pv_M2_2 = -2.811461617433e-08
alterparam pv_M3_0 = -1.422804219965e-07
alterparam pv_M3_1 = -4.825293691249e-08
alterparam pv_M3_2 = 7.235402360527e-07
alterparam pv_M3_3 = 9.292122010945e-07
alterparam pv_M4_0 = -1.128572752641e-07
alterparam pv_M4_1 = -7.282970528911e-07
alterparam pv_M4_2 = -1.068644540226e-06
alterparam pv_M4_3 = -1.579378258566e-06
reset
op
echo MCS 128
print v(inn)
print v(inp)
print v(out)
alterparam pv_M1_0 = -8.315264273997e-07
alterparam pv_M1_1 = -6.026810408473e-07
alterparam pv_M1_2 = -3.714824286368e-08
alterparam pv_M2_0 = -1.329741757116e-06
alterparam pv_M2_1 = 1.010944343464e-06
alterparam pv_M2_2 = 7.520474800067e-07
alterparam pv_M3_0 = 8.804684041936e-07
alterparam pv_M3_1 = -3.626681488555e-07
alterparam pv_M3_2 = 1.725349463276e-07
alterparam pv_M3_3 = -6.698877339424e-07
alterparam pv_M4_0 = 1.095880853385e-06
alterparam pv_M4_1 = -8.577382474714e-07
alterparam pv_M4_2 = -3.631879485577e-07
alterparam pv_M4_3 = 1.006507017729e-06
reset
op
echo MCS 129
print v(inn)
print v(inp)
print v(out)
alterparam pv_M1_0 = 1.760563028805e-06
alterparam pv_M1_1 = -6.486041525968e-08
alterparam pv_M1_2 = -2.929078299753e-07
alterparam pv_M2_0 = -1.772809993969e-06
alterparam pv_M2_1 = 1.209472219779e-06
alterparam pv_M2_2 = 2.179177078994e-07
alterparam pv_M3_0 = -1.332147329531e-06
alterparam pv_M3_1 = 6.161423682112e-07
alterparam pv_M3_2 = 4.340796173735e-07
alterparam pv_M3_3 = -2.505983767831e-07
alterparam pv_M4_0 = -3.944498792504e-07
alterparam pv_M4_1 = 5.162765683079e-07
alterparam pv_M4_2 = 1.654243319672e-07
alterparam pv_M4_3 = 3.442433695945e-07
reset
op
echo MCS 130
print v(inn)
print v(inp)
print v(out)
alterparam pv_M1_0 = 8.672627425180e-07
alterparam pv_M1_1 = 8.437127073017e-07
alterparam pv_M1_2 = 5.377639740608e-07
alterparam pv_M2_0 = 4.138587831843e-07
alterparam pv_M2_1 = -9.038130857934e-07
alterparam pv_M2_2 = -7.887487411363e-07
alterparam pv_M3_0 = 5.787829644559e-07
alterparam pv_M3_1 = 4.576414734428e-07
alterparam pv_M3_2 = 3.664098229024e-07
alterparam pv_M3_3 = 5.942151964736e-07
alterparam pv_M4_0 = -3.917395232586e-07
alterparam pv_M4_1 = 3.994611897766e-07
alterparam pv_M4_2 = -6.992444694871e-07
alterparam pv_M4_3 = 4.410942012022e-08
reset
op
echo MCS 131
print v(inn)
print v(inp)
print v(out)
alterparam pv_M1_0 = 6.571326811265e-07
alterparam pv_M1_1 = -4.786154551829e-07
alterparam pv_M1_2 = 1.380914442808e-06
alterparam pv_M2_0 = 8.019153005342e-07
alterparam pv_M2_1 = 9.702262734049e-07
alterparam pv_M2_2 = -1.493101232085e-07
alterparam pv_M3_0 = -9.821355659750e-07
alterparam pv_M3_1 = -4.939776065736e-07
alterparam pv_M3_2 = 3.900874566068e-07
alterparam pv_M3_3 = -1.972849368745e-07
alterparam pv_M4_0 = 5.100822022582e-07
alterparam pv_M4_1 = 1.063876923411e-07
alterparam pv_M4_2 = -4.170188781189e-07
alterparam pv_M4_3 = 6.605899659821e-07
reset
op
echo MCS 132
print v(inn)
print v(inp)
print v(out)
alterparam pv_M1_0 = 9.558278437590e-07
alterparam pv_M1_1 = -5.177076728840e-07
alterparam pv_M1_2 = 3.619733508720e-07
alterparam pv_M2_0 = 1.107288059741e-07
alterparam pv_M2_1 = 1.986119120085e-07
alterparam pv_M2_2 = -7.361509487115e-08
alterparam pv_M3_0 = -8.857795344299e-07
alterparam pv_M3_1 = 9.966838072091e-07
alterparam pv_M3_2 = -7.379308860034e-07
alterparam pv_M3_3 = -6.156257875865e-07
alterparam pv_M4_0 = 4.640533861960e-07
alterparam pv_M4_1 = 1.271906907328e-07
alterparam pv_M4_2 = -5.628831904344e-07
alterparam pv_M4_3 = -4.649562088609e-07
reset
op
echo MCS 133
print v(inn)
print v(inp)
print v(out)
alterparam pv_M1_0 = -1.122160719282e-07
alterparam pv_M1_1 = -3.083566666107e-07
alterparam pv_M1_2 = 4.571631479513e-07
alterparam pv_M2_0 = -8.232272333063e-07
alterparam pv_M2_1 = 2.569065159726e-07
alterparam pv_M2_2 = 1.082251548566e-06
alterparam pv_M3_0 = 1.423845718366e-07
alterparam pv_M3_1 = -6.281182925858e-07
alterparam pv_M3_2 = -5.112654135220e-07
alterparam pv_M3_3 = 3.087544712744e-08
alterparam pv_M4_0 = -4.413860139828e-07
alterparam pv_M4_1 = 8.729956386018e-07
alterparam pv_M4_2 = -1.301347792461e-06
alterparam pv_M4_3 = 1.158921722737e-06
reset
op
echo MCS 134
print v(inn)
print v(inp)
print v(out)
alterparam pv_M1_0 = -1.431884028975e-06
alterparam pv_M1_1 = -2.899765238742e-08
alterparam pv_M1_2 = -7.657769896603e-07
alterparam pv_M2_0 = 5.799571299532e-07
alterparam pv_M2_1 = -5.473244615745e-07
alterparam pv_M2_2 = -8.011999587294e-07
alterparam pv_M3_0 = -2.404339706504e-07
alterparam pv_M3_1 = -2.906270415581e-07
alterparam pv_M3_2 = -1.368272928339e-06
alterparam pv_M3_3 = 3.213914474221e-07
alterparam pv_M4_0 = -1.691841709770e-06
alterparam pv_M4_1 = 8.317960904455e-07
alterparam pv_M4_2 = -2.333911112756e-07
alterparam pv_M4_3 = 6.738775561699e-07
reset
op
echo MCS 135
print v(inn)
print v(inp)
print v(out)
alterparam pv_M1_0 = -4.246587651964e-07
alterparam pv_M1_1 = -5.608113851482e-07
alterparam pv_M1_2 = 4.608555304373e-07
alterparam pv_M2_0 = -4.130491837405e-07
alterparam pv_M2_1 = -1.094322754481e-06
alterparam pv_M2_2 = -6.157264927258e-08
alterparam pv_M3_0 = -9.737352563695e-07
alterparam pv_M3_1 = -9.126784319949e-09
alterparam pv_M3_2 = 9.750574722018e-07
alterparam pv_M3_3 = 6.807093363045e-07
alterparam pv_M4_0 = 1.309371647982e-09
alterparam pv_M4_1 = -1.171808362691e-07
alterparam pv_M4_2 = -2.240011019238e-07
alterparam pv_M4_3 = -4.508126726645e-07
reset
op
echo MCS 136
print v(inn)
print v(inp)
print v(out)
alterparam pv_M1_0 = 2.510751503661e-07
alterparam pv_M1_1 = -1.116416220808e-07
alterparam pv_M1_2 = -2.699020587246e-07
alterparam pv_M2_0 = 1.909525879534e-07
alterparam pv_M2_1 = -1.427207873815e-06
alterparam pv_M2_2 = 1.383440402440e-06
alterparam pv_M3_0 = 4.455719130962e-07
alterparam pv_M3_1 = -9.855394958620e-07
alterparam pv_M3_2 = 8.135016826597e-08
alterparam pv_M3_3 = -7.983837652813e-07
alterparam pv_M4_0 = -3.813203004601e-07
alterparam pv_M4_1 = -6.329379432003e-07
alterparam pv_M4_2 = 7.720622004278e-07
alterparam pv_M4_3 = -1.358163659468e-06
reset
op
echo MCS 137
print v(inn)
print v(inp)
print v(out)
alterparam pv_M1_0 = -2.505939785276e-07
alterparam pv_M1_1 = -1.166063604292e-06
alterparam pv_M1_2 = -1.446006589576e-08
alterparam pv_M2_0 = -2.246534940320e-07
alterparam pv_M2_1 = -9.947011929398e-07
alterparam pv_M2_2 = 1.018045967794e-06
alterparam pv_M3_0 = 1.105521088862e-06
alterparam pv_M3_1 = -3.989372734003e-07
alterparam pv_M3_2 = 3.690589639021e-07
alterparam pv_M3_3 = -1.052222115685e-07
alterparam pv_M4_0 = 1.721385753972e-07
alterparam pv_M4_1 = 1.083380194383e-06
alterparam pv_M4_2 = -1.899575997124e-07
alterparam pv_M4_3 = 1.267253780653e-06
reset
op
echo MCS 138
print v(inn)
print v(inp)
print v(out)
alterparam pv_M1_0 = -2.037845351637e-07
alterparam pv_M1_1 = -6.615262138090e-08
alterparam pv_M1_2 = 1.335949171906e-06
alterparam pv_M2_0 = 1.946079465257e-07
alterparam pv_M2_1 = -1.436799708170e-06
alterparam pv_M2_2 = 1.589596372751e-07
alterparam pv_M3_0 = -9.064071112885e-07
alterparam pv_M3_1 = -1.175637780671e-06
alterparam pv_M3_2 = -6.665491610502e-07
alterparam pv_M3_3 = 2.305736484681e-07
alterparam pv_M4_0 = -7.872698169743e-07
alterparam pv_M4_1 = -9.908393937911e-07
alterparam pv_M4_2 = -2.685319546250e-07
alterparam pv_M4_3 = 2.861029331307e-07
reset
op
echo MCS 139
print v(inn)
print v(inp)
print v(out)
alterparam pv_M1_0 = -4.924138069190e-07
alterparam pv_M1_1 = -9.237900272313e-07
alterparam pv_M1_2 = -1.536325680802e-06
alterparam pv_M2_0 = -5.488580427833e-07
alterparam pv_M2_1 = 5.970162245078e-07
alterparam pv_M2_2 = 7.085847907379e-07
alterparam pv_M3_0 = 5.584810332419e-07
alterparam pv_M3_1 = -1.239496260518e-07
alterparam pv_M3_2 = 9.146524058449e-08
alterparam pv_M3_3 = 8.964017028746e-07
alterparam pv_M4_0 = -6.142476994347e-07
alterparam pv_M4_1 = 2.574403087045e-07
alterparam pv_M4_2 = -1.322923528533e-06
alterparam pv_M4_3 = 4.824573036700e-07
reset
op
echo MCS 140
print v(inn)
print v(inp)
print v(out)
alterparam pv_M1_0 = -3.189355913019e-07
alterparam pv_M1_1 = -8.171548242575e-07
alterparam pv_M1_2 = 5.464761255508e-07
alterparam pv_M2_0 = -7.857617701674e-07
alterparam pv_M2_1 = -6.132607557947e-07
alterparam pv_M2_2 = 1.086694727309e-06
alterparam pv_M3_0 = -7.396514304349e-07
alterparam pv_M3_1 = -4.638656028959e-07
alterparam pv_M3_2 = -4.831338859929e-07
alterparam pv_M3_3 = 5.549380752716e-07
alterparam pv_M4_0 = -1.298185610834e-06
alterparam pv_M4_1 = 8.841632666071e-07
alterparam pv_M4_2 = -1.720771674838e-07
alterparam pv_M4_3 = -2.240583482117e-07
reset
op
echo MCS 141
print v(inn)
print v(inp)
print v(out)
alterparam pv_M1_0 = -6.340495104590e-07
alterparam pv_M1_1 = -1.028496201263e-07
alterparam pv_M1_2 = 1.039725230769e-06
alterparam pv_M2_0 = 1.505093658480e-07
alterparam pv_M2_1 = -6.594054933987e-07
alterparam pv_M2_2 = -2.456171909898e-07
alterparam pv_M3_0 = 3.779153876043e-07
alterparam pv_M3_1 = 6.033393714898e-08
alterparam pv_M3_2 = -1.819460641517e-07
alterparam pv_M3_3 = 4.274976066067e-07
alterparam pv_M4_0 = 2.553268436381e-07
alterparam pv_M4_1 = -7.620603022361e-07
alterparam pv_M4_2 = -1.354050338108e-06
alterparam pv_M4_3 = 3.538986024083e-07
reset
op
echo MCS 142
print v(inn)
print v(inp)
print v(out)
alterparam pv_M1_0 = 1.313411333866e-06
alterparam pv_M1_1 = -5.803447344183e-07
alterparam pv_M1_2 = -9.971034149850e-08
alterparam pv_M2_0 = 9.574801278479e-07
alterparam pv_M2_1 = 1.230106973744e-06
alterparam pv_M2_2 = 4.612873855282e-08
alterparam pv_M3_0 = 8.836892159115e-07
alterparam pv_M3_1 = 5.307783708809e-07
alterparam pv_M3_2 = -3.930210720339e-07
alterparam pv_M3_3 = -1.427515384970e-06
alterparam pv_M4_0 = -6.430623958032e-07
alterparam pv_M4_1 = 2.610845640500e-07
alterparam pv_M4_2 = 2.964579363158e-07
alterparam pv_M4_3 = -3.551405283289e-07
reset
op
echo MCS 143
print v(inn)
print v(inp)
print v(out)
alterparam pv_M1_0 = -6.064854575073e-07
alterparam pv_M1_1 = -1.131586687208e-06
alterparam pv_M1_2 = -1.188175337929e-06
alterparam pv_M2_0 = -8.635196503376e-08
alterparam pv_M2_1 = -1.113505035798e-06
alterparam pv_M2_2 = -1.068154777371e-08
alterparam pv_M3_0 = -5.642576857853e-07
alterparam pv_M3_1 = -3.013438380282e-07
alterparam pv_M3_2 = 1.502861908969e-06
alterparam pv_M3_3 = 3.412676197873e-08
alterparam pv_M4_0 = -2.429285983030e-07
alterparam pv_M4_1 = -1.225669428991e-07
alterparam pv_M4_2 = -1.042033008214e-06
alterparam pv_M4_3 = 9.469215251717e-07
reset
op
echo MCS 144
print v(inn)
print v(inp)
print v(out)
alterparam pv_M1_0 = 5.994967392321e-07
alterparam pv_M1_1 = -3.761773652007e-07
alterparam pv_M1_2 = 1.621312191011e-07
alterparam pv_M2_0 = -4.748771640153e-07
alterparam pv_M2_1 = 2.802131446926e-07
alterparam pv_M2_2 = -9.496251161696e-07
alterparam pv_M3_0 = 1.891303476941e-07
alterparam pv_M3_1 = 1.061558083116e-06
alterparam pv_M3_2 = 3.155685153810e-07
alterparam pv_M3_3 = -4.172562071379e-07
alterparam pv_M4_0 = 6.715887930272e-07
alterparam pv_M4_1 = 1.379242179708e-06
alterparam pv_M4_2 = 5.168484114601e-07
alterparam pv_M4_3 = 6.875482986893e-08
reset
op
echo MCS 145
print v(inn)
print v(inp)
print v(out)
alterparam pv_M1_0 = -5.672540187913e-07
alterparam pv_M1_1 = 3.080433117398e-07
alterparam pv_M1_2 = 1.359247850540e-06
alterparam pv_M2_0 = -1.426149643427e-06
alterparam pv_M2_1 = 6.910479773580e-07
alterparam pv_M2_2 = 1.045046363478e-07
alterparam pv_M3_0 = 1.070104769430e-06
alterparam pv_M3_1 = -9.046371745100e-08
alterparam pv_M3_2 = -1.529982852533e-06
alterparam pv_M3_3 = 1.408158883363e-06
alterparam pv_M4_0 = -8.198075064695e-07
alterparam pv_M4_1 = 5.659118559795e-07
alterparam pv_M4_2 = -9.020581283837e-08
alterparam pv_M4_3 = -2.799173807000e-08
reset
op
echo MCS 146
print v(inn)
print v(inp)
print v(out)
alterparam pv_M1_0 = 9.731476227934e-08
alterparam pv_M1_1 = -3.859855982254e-07
alterparam pv_M1_2 = 1.319347105939e-07
alterparam pv_M2_0 = 2.175590928738e-07
alterparam pv_M2_1 = 5.668171929993e-07
alterparam pv_M2_2 = 8.840355764809e-08
alterparam pv_M3_0 = 2.253493863618e-07
alterparam pv_M3_1 = 9.391682817813e-07
alterparam pv_M3_2 = -6.378257383452e-07
alterparam pv_M3_3 = 4.959922515884e-08
alterparam pv_M4_0 = 3.382180223449e-07
alterparam pv_M4_1 = 7.321641016563e-07
alterparam pv_M4_2 = -4.495936442453e-08
alterparam pv_M4_3 = 7.025027112790e-08
reset
op
echo MCS 147
print v(inn)
print v(inp)
print v(out)
alterparam pv_M1_0 = -2.439143148575e-07
alterparam pv_M1_1 = 8.769934474806e-07
alterparam pv_M1_2 = -2.271029349070e-07
alterparam pv_M2_0 = 4.845750444510e-07
alterparam pv_M2_1 = -7.203657343040e-08
alterparam pv_M2_2 = 2.181050625416e-08
alterparam pv_M3_0 = -8.648327579158e-07
alterparam pv_M3_1 = 4.010149554252e-08
alterparam pv_M3_2 = -2.096294755998e-08
alterparam pv_M3_3 = -1.049063963690e-06
alterparam pv_M4_0 = -5.235704244422e-07
alterparam pv_M4_1 = -3.209220290085e-07
alterparam pv_M4_2 = -1.080957380984e-06
alterparam pv_M4_3 = -8.606647540815e-07
reset
op
echo MCS 148
print v(inn)
print v(inp)
print v(out)
alterparam pv_M1_0 = 1.039138178737e-06
alterparam pv_M1_1 = -7.283075563377e-07
alterparam pv_M1_2 = -6.057628117502e-07
alterparam pv_M2_0 = -9.869521467122e-07
alterparam pv_M2_1 = 8.678900774267e-07
alterparam pv_M2_2 = 6.492712189491e-07
alterparam pv_M3_0 = 2.250131287086e-07
alterparam pv_M3_1 = 5.956717254979e-08
alterparam pv_M3_2 = -3.478072637900e-07
alterparam pv_M3_3 = -2.011076461168e-07
alterparam pv_M4_0 = -4.766993883497e-07
alterparam pv_M4_1 = 4.654653579962e-07
alterparam pv_M4_2 = 4.894553368114e-07
alterparam pv_M4_3 = 6.453257469772e-07
reset
op
echo MCS 149
print v(inn)
print v(inp)
print v(out)
alterparam pv_M1_0 = 1.448787572581e-06
alterparam pv_M1_1 = 5.000437354377e-07
alterparam pv_M1_2 = 4.486793478087e-07
alterparam pv_M2_0 = 7.097216458468e-07
alterparam pv_M2_1 = -1.090365627140e-06
alterparam pv_M2_2 = 3.346357673742e-09
alterparam pv_M3_0 = -1.069501055648e-06
alterparam pv_M3_1 = 1.115285699756e-06
alterparam pv_M3_2 = -3.486104432496e-07
alterparam pv_M3_3 = 1.253785720102e-06
alterparam pv_M4_0 = 7.506101826648e-07
alterparam pv_M4_1 = -3.904899658917e-07
alterparam pv_M4_2 = -1.173632142782e-06
alterparam pv_M4_3 = -7.948002788648e-07
reset
op
echo MCS 150
print v(inn)
print v(inp)
print v(out)
alterparam pv_M1_0 = 7.344868065845e-07
alterparam pv_M1_1 = -2.271952506167e-07
alterparam pv_M1_2 = -1.047426736313e-06
alterparam pv_M2_0 = -1.588951744188e-07
alterparam pv_M2_1 = 1.196923890152e-06
alterparam pv_M2_2 = 1.137902298655e-06
alterparam pv_M3_0 = -3.345224263674e-07
alterparam pv_M3_1 = 2.178703475577e-07
alterparam pv_M3_2 = 4.332766679188e-07
alterparam pv_M3_3 = -1.045927710516e-06
alterparam pv_M4_0 = -3.768331032465e-07
alterparam pv_M4_1 = -2.866705491238e-07
alterparam pv_M4_2 = 2.857080411579e-07
alterparam pv_M4_3 = -3.608375264145e-07
reset
op
echo MCS 151
print v(inn)
print v(inp)
print v(out)
alterparam pv_M1_0 = -9.881018211822e-07
alterparam pv_M1_1 = 2.292488360717e-07
alterparam pv_M1_2 = -4.539677571191e-07
alterparam pv_M2_0 = -8.682537226302e-07
alterparam pv_M2_1 = -8.664863866435e-07
alterparam pv_M2_2 = -1.576694877372e-07
alterparam pv_M3_0 = 1.026052261596e-06
alterparam pv_M3_1 = -1.234226455579e-07
alterparam pv_M3_2 = 7.588140239967e-07
alterparam pv_M3_3 = -1.588254853239e-06
alterparam pv_M4_0 = -5.930229217794e-07
alterparam pv_M4_1 = -8.895331446059e-07
alterparam pv_M4_2 = -1.941398340425e-07
alterparam pv_M4_3 = 5.446099719159e-07
reset
op
echo MCS 152
print v(inn)
print v(inp)
print v(out)
alterparam pv_M1_0 = -3.864103922512e-07
alterparam pv_M1_1 = -8.799885018293e-07
alterparam pv_M1_2 = 6.701529683724e-07
alterparam pv_M2_0 = -5.389090640934e-07
alterparam pv_M2_1 = 1.927276851445e-07
alterparam pv_M2_2 = -4.702240753296e-07
alterparam pv_M3_0 = 3.656636703698e-07
alterparam pv_M3_1 = -2.712087935225e-07
alterparam pv_M3_2 = 5.622614893367e-07
alterparam pv_M3_3 = 4.391164371904e-07
alterparam pv_M4_0 = 1.570674692240e-06
alterparam pv_M4_1 = -5.669186059621e-08
alterparam pv_M4_2 = -6.896633987763e-07
alterparam pv_M4_3 = -8.210338864173e-07
reset
op
echo MCS 153
print v(inn)
print v(inp)
print v(out)
alterparam pv_M1_0 = -4.223669590281e-07
alterparam pv_M1_1 = 2.653872935361e-07
alterparam pv_M1_2 = -5.047505088972e-07
alterparam pv_M2_0 = 1.074072247026e-06
alterparam pv_M2_1 = 1.416463332581e-07
alterparam pv_M2_2 = -6.908567285287e-07
alterparam pv_M3_0 = -3.273573825459e-07
alterparam pv_M3_1 = -4.514031463323e-07
alterparam pv_M3_2 = 1.260539867269e-07
alterparam pv_M3_3 = -7.250486382191e-07
alterparam pv_M4_0 = 9.064856588070e-07
alterparam pv_M4_1 = -2.519487564780e-07
alterparam pv_M4_2 = -1.677820719507e-07
alterparam pv_M4_3 = 6.527655924203e-07
reset
op
echo MCS 154
print v(inn)
print v(inp)
print v(out)
alterparam pv_M1_0 = -5.292496137893e-07
alterparam pv_M1_1 = -9.695830581459e-10
alterparam pv_M1_2 = 1.267286529444e-06
alterparam pv_M2_0 = 2.907221536762e-07
alterparam pv_M2_1 = 2.077641955864e-07
alterparam pv_M2_2 = -3.368623837991e-07
alterparam pv_M3_0 = -7.030338813296e-07
alterparam pv_M3_1 = 1.236594734700e-06
alterparam pv_M3_2 = -1.132134092197e-07
alterparam pv_M3_3 = 1.342082556478e-06
alterparam pv_M4_0 = -4.835866149922e-07
alterparam pv_M4_1 = 8.873856234646e-07
alterparam pv_M4_2 = -1.451808790573e-07
alterparam pv_M4_3 = 2.947092142987e-07
reset
op
echo MCS 155
print v(inn)
print v(inp)
print v(out)
alterparam pv_M1_0 = 8.603429313526e-07
alterparam pv_M1_1 = 3.122121174815e-07
alterparam pv_M1_2 = 5.675076521938e-07
alterparam pv_M2_0 = -1.105158142858e-06
alterparam pv_M2_1 = -3.257651744091e-07
alterparam pv_M2_2 = 1.445813397095e-06
alterparam pv_M3_0 = -1.620239118077e-07
alterparam pv_M3_1 = 2.253051723036e-07
alterparam pv_M3_2 = -1.153218796411e-07
alterparam pv_M3_3 = -4.395220349536e-07
alterparam pv_M4_0 = -1.056459154575e-06
alterparam pv_M4_1 = -8.073333358321e-07
alterparam pv_M4_2 = 1.189756852530e-06
alterparam pv_M4_3 = -5.590431246158e-08
reset
op
echo MCS 156
print v(inn)
print v(inp)
print v(out)
alterparam pv_M1_0 = -8.406146476962e-07
alterparam pv_M1_1 = -6.392707779236e-07
alterparam pv_M1_2 = 6.176072998330e-07
alterparam pv_M2_0 = -6.697361418653e-07
alterparam pv_M2_1 = -4.421905201504e-07
alterparam pv_M2_2 = -7.895791907928e-07
alterparam pv_M3_0 = -8.903395176485e-07
alterparam pv_M3_1 = 1.166062385154e-06
alterparam pv_M3_2 = -9.962396245893e-08
alterparam pv_M3_3 = -2.273397220455e-07
alterparam pv_M4_0 = -4.252891097226e-07
alterparam pv_M4_1 = 5.037802663512e-07
alterparam pv_M4_2 = 4.346679193649e-08
alterparam pv_M4_3 = 2.067166977645e-07
reset
op
echo MCS 157
print v(inn)
print v(inp)
print v(out)
alterparam pv_M1_0 = 9.677877115520e-08
alterparam pv_M1_1 = -2.526645821775e-07
alterparam pv_M1_2 = -3.400394990074e-07
alterparam pv_M2_0 = -1.226761055036e-06
alterparam pv_M2_1 = -3.477397191019e-07
alterparam pv_M2_2 = 1.529866471097e-06
alterparam pv_M3_0 = -8.764140387529e-07
alterparam pv_M3_1 = 3.091362550412e-09
alterparam pv_M3_2 = 2.373937246977e-07
alterparam pv_M3_3 = 8.443032560357e-07
alterparam pv_M4_0 = 1.879685409504e-06
alterparam pv_M4_1 = -2.805770943608e-07
alterparam pv_M4_2 = -6.202056825307e-07
alterparam pv_M4_3 = 7.496549522761e-07
reset
op
echo MCS 158
print v(inn)
print v(inp)
print v(out)
alterparam pv_M1_0 = 1.506200376742e-07
alterparam pv_M1_1 = 1.418723484740e-06
alterparam pv_M1_2 = 5.128907558142e-07
alterparam pv_M2_0 = -4.729109827700e-07
alterparam pv_M2_1 = -1.390420242042e-07
alterparam pv_M2_2 = 2.991336437774e-07
alterparam pv_M3_0 = 3.540404876443e-07
alterparam pv_M3_1 = -8.019406297704e-07
alterparam pv_M3_2 = -1.360619518854e-06
alterparam pv_M3_3 = -1.134041434585e-06
alterparam pv_M4_0 = 4.363980995800e-07
alterparam pv_M4_1 = -1.083558131883e-07
alterparam pv_M4_2 = -1.297428858790e-06
alterparam pv_M4_3 = -3.895028748269e-07
reset
op
echo MCS 159
print v(inn)
print v(inp)
print v(out)
alterparam pv_M1_0 = -1.369676631545e-06
alterparam pv_M1_1 = -1.860953309488e-07
alterparam pv_M1_2 = -6.119016469910e-07
alterparam pv_M2_0 = -3.945414007165e-07
alterparam pv_M2_1 = -5.964790580699e-08
alterparam pv_M2_2 = 1.291388881800e-07
alterparam pv_M3_0 = 4.211200584732e-08
alterparam pv_M3_1 = 9.133540382272e-07
alterparam pv_M3_2 = 1.697783443107e-06
alterparam pv_M3_3 = 6.024297909496e-07
alterparam pv_M4_0 = -1.340903435157e-07
alterparam pv_M4_1 = 5.317215222133e-07
alterparam pv_M4_2 = -5.142550694105e-07
alterparam pv_M4_3 = -5.839550764135e-07
reset
op
echo MCS 160
print v(inn)
print v(inp)
print v(out)
alterparam pv_M1_0 = -6.160629620339e-07
alterparam pv_M1_1 = 2.067293531389e-07
alterparam pv_M1_2 = 8.757558364544e-07
alterparam pv_M2_0 = 1.572701476678e-06
alterparam pv_M2_1 = 9.364013817534e-07
alterparam pv_M2_2 = 4.933394680834e-07
alterparam pv_M3_0 = -4.867204743617e-07
alterparam pv_M3_1 = 5.419846856443e-08
alterparam pv_M3_2 = 3.842837459514e-07
alterparam pv_M3_3 = -8.644598327393e-08
alterparam pv_M4_0 = 1.317242124273e-06
alterparam pv_M4_1 = -5.797927310117e-07
alterparam pv_M4_2 = -5.049716875561e-07
alterparam pv_M4_3 = 2.687323895926e-07
reset
op
echo MCS 161
print v(inn)
print v(inp)
print v(out)
alterparam pv_M1_0 = 1.419022203953e-06
alterparam pv_M1_1 = -1.281802440574e-06
alterparam pv_M1_2 = -5.982407697599e-07
alterparam pv_M2_0 = 9.106849533140e-07
alterparam pv_M2_1 = -4.800908609369e-07
alterparam pv_M2_2 = 1.455999887359e-06
alterparam pv_M3_0 = -5.809021262373e-07
alterparam pv_M3_1 = 7.582489885642e-07
alterparam pv_M3_2 = -6.235089209511e-08
alterparam pv_M3_3 = 3.249572435953e-07
alterparam pv_M4_0 = -7.324813773744e-07
alterparam pv_M4_1 = -1.135760218490e-06
alterparam pv_M4_2 = 5.483963581533e-07
alterparam pv_M4_3 = -3.742769888047e-07
reset
op
echo MCS 162
print v(inn)
print v(inp)
print v(out)
alterparam pv_M1_0 = -6.496140862866e-07
alterparam pv_M1_1 = -7.815600683699e-07
alterparam pv_M1_2 = -7.389518733824e-07
alterparam pv_M2_0 = 9.568757478027e-07
alterparam pv_M2_1 = -6.524073197248e-07
alterparam pv_M2_2 = -3.835862273314e-07
alterparam pv_M3_0 = 1.390655880000e-06
alterparam pv_M3_1 = -3.056935019116e-07
alterparam pv_M3_2 = -3.999657866607e-09
alterparam pv_M3_3 = 2.599684458988e-07
alterparam pv_M4_0 = -2.093029635763e-07
alterparam pv_M4_1 = -4.865790114861e-07
alterparam pv_M4_2 = 9.043081328927e-07
alterparam pv_M4_3 = 2.261544581145e-07
reset
op
echo MCS 163
print v(inn)
print v(inp)
print v(out)
alterparam pv_M1_0 = -4.451191965728e-07
alterparam pv_M1_1 = -9.795536797355e-07
alterparam pv_M1_2 = -8.185977665767e-07
alterparam pv_M2_0 = -7.244629985025e-07
alterparam pv_M2_1 = -1.524510905333e-06
alterparam pv_M2_2 = 8.300998108107e-07
alterparam pv_M3_0 = 7.219609255199e-08
alterparam pv_M3_1 = 3.794715866058e-07
alterparam pv_M3_2 = -1.003295648270e-06
alterparam pv_M3_3 = -3.430229427827e-07
alterparam pv_M4_0 = -1.697759975985e-07
alterparam pv_M4_1 = 5.345004619410e-08
alterparam pv_M4_2 = -1.458662016549e-07
alterparam pv_M4_3 = -8.802944578227e-07
reset
op
echo MCS 164
print v(inn)
print v(inp)
print v(out)
alterparam pv_M1_0 = 7.720539917967e-07
alterparam pv_M1_1 = 5.022466486416e-07
alterparam pv_M1_2 = 5.293402975709e-08
alterparam pv_M2_0 = 7.298995203016e-07
alterparam pv_M2_1 = 8.542581288643e-07
alterparam pv_M2_2 = 9.856406667385e-07
alterparam pv_M3_0 = 1.152763620188e-07
alterparam pv_M3_1 = -2.225937056449e-07
alterparam pv_M3_2 = -3.392782718505e-07
alterparam pv_M3_3 = 6.301968862149e-07
alterparam pv_M4_0 = -4.960105850185e-07
alterparam pv_M4_1 = -6.459605166564e-07
alterparam pv_M4_2 = 3.920178157142e-07
alterparam pv_M4_3 = 3.698197983084e-07
reset
op
echo MCS 165
print v(inn)
print v(inp)
print v(out)
alterparam pv_M1_0 = 4.501085640318e-07
alterparam pv_M1_1 = -6.004878356192e-07
alterparam pv_M1_2 = 2.126533156051e-07
alterparam pv_M2_0 = 6.472128594061e-07
alterparam pv_M2_1 = -3.392920838001e-07
alterparam pv_M2_2 = -1.896024460457e-07
alterparam pv_M3_0 = -2.106853327365e-07
alterparam pv_M3_1 = 1.074249619016e-06
alterparam pv_M3_2 = 6.369678801519e-07
alterparam pv_M3_3 = -9.479260439524e-07
alterparam pv_M4_0 = -1.075333708483e-06
alterparam pv_M4_1 = 4.596976912183e-07
alterparam pv_M4_2 = -1.506866420736e-07
alterparam pv_M4_3 = 3.765856089798e-07
reset
op
echo MCS 166
print v(inn)
print v(inp)
print v(out)
alterparam pv_M1_0 = 1.878750413305e-07
alterparam pv_M1_1 = 7.138956255854e-07
alterparam pv_M1_2 = -1.149554116972e-06
alterparam pv_M2_0 = -3.873976466250e-07
alterparam pv_M2_1 = 1.774796098516e-07
alterparam pv_M2_2 = 1.657949964303e-07
alterparam pv_M3_0 = -6.704357690516e-07
alterparam pv_M3_1 = -3.727576613267e-07
alterparam pv_M3_2 = -4.142534285969e-07
alterparam pv_M3_3 = 3.159294187063e-08
alterparam pv_M4_0 = 4.953737323551e-07
alterparam pv_M4_1 = -1.947856415627e-07
alterparam pv_M4_2 = -1.082255597302e-07
alterparam pv_M4_3 = -1.480807114546e-06
reset
op
echo MCS 167
print v(inn)
print v(inp)
print v(out)
alterparam pv_M1_0 = -7.503134366694e-07
alterparam pv_M1_1 = 1.310254762450e-06
alterparam pv_M1_2 = -1.212481390816e-06
alterparam pv_M2_0 = 9.647707231441e-07
alterparam pv_M2_1 = -2.106413053658e-07
alterparam pv_M2_2 = -1.388193269200e-06
alterparam pv_M3_0 = 1.030738653341e-06
alterparam pv_M3_1 = 9.079738215562e-07
alterparam pv_M3_2 = -3.558502306284e-07
alterparam pv_M3_3 = 6.132574411971e-07
alterparam pv_M4_0 = -2.516554398522e-07
alterparam pv_M4_1 = 3.601031365312e-08
alterparam pv_M4_2 = 1.175702908238e-07
alterparam pv_M4_3 = -1.633491287270e-07
reset
op
echo MCS 168
print v(inn)
print v(inp)
print v(out)
alterparam pv_M1_0 = 3.707874367389e-07
alterparam pv_M1_1 = 2.727657376224e-07
alterparam pv_M1_2 = -3.697354504672e-07
alterparam pv_M2_0 = 2.092987709677e-07
alterparam pv_M2_1 = -3.681109715285e-07
alterparam pv_M2_2 = 9.462407933548e-08
alterparam pv_M3_0 = -3.513398629758e-07
alterparam pv_M3_1 = 6.879489537827e-08
alterparam pv_M3_2 = 1.131827563224e-06
alterparam pv_M3_3 = -4.623710593891e-07
alterparam pv_M4_0 = -1.034587057791e-06
alterparam pv_M4_1 = 1.127231067382e-06
alterparam pv_M4_2 = 2.067894219475e-07
alterparam pv_M4_3 = -4.600537018255e-07
reset
op
echo MCS 169
print v(inn)
print v(inp)
print v(out)
alterparam pv_M1_0 = -1.765291600235e-07
alterparam pv_M1_1 = -6.461195718842e-07
alterparam pv_M1_2 = 6.631557418035e-07
alterparam pv_M2_0 = 5.044068500249e-07
alterparam pv_M2_1 = 4.444677764577e-07
alterparam pv_M2_2 = 1.557073369811e-07
alterparam pv_M3_0 = -1.449598348352e-06
alterparam pv_M3_1 = -8.393204724225e-07
alterparam pv_M3_2 = 2.011013857689e-07
alterparam pv_M3_3 = -1.877332380938e-06
alterparam pv_M4_0 = -5.604218258553e-08
alterparam pv_M4_1 = -7.250053278596e-07
alterparam pv_M4_2 = 4.478062700577e-07
alterparam pv_M4_3 = -1.390181692983e-07
reset
op
echo MCS 170
print v(inn)
print v(inp)
print v(out)
alterparam pv_M1_0 = 7.487681793563e-07
alterparam pv_M1_1 = 2.387579064503e-07
alterparam pv_M1_2 = 8.043251390789e-08
alterparam pv_M2_0 = -6.882549834743e-07
alterparam pv_M2_1 = 4.438570228973e-07
alterparam pv_M2_2 = 1.682406866896e-06
alterparam pv_M3_0 = -1.209466866239e-06
alterparam pv_M3_1 = -7.238895310057e-07
alterparam pv_M3_2 = 1.176691220822e-06
alterparam pv_M3_3 = 3.618910504851e-07
alterparam pv_M4_0 = -2.092538406476e-07
alterparam pv_M4_1 = 5.529422491973e-07
alterparam pv_M4_2 = 2.351074206163e-07
alterparam pv_M4_3 = -4.614734016036e-07
reset
op
echo MCS 171
print v(inn)
print v(inp)
print v(out)
alterparam pv_M1_0 = -4.725530355167e-07
alterparam pv_M1_1 = 6.047709427607e-07
alterparam pv_M1_2 = 2.427530947483e-07
alterparam pv_M2_0 = 7.620365903480e-07
alterparam pv_M2_1 = 4.622927999834e-07
alterparam pv_M2_2 = -4.341602490121e-07
alterparam pv_M3_0 = 1.077712873562e-06
alterparam pv_M3_1 = -6.527747562479e-07
alterparam pv_M3_2 = -3.205280224296e-07
alterparam pv_M3_3 = -5.535105740929e-07
alterparam pv_M4_0 = -9.907840016348e-07
alterparam pv_M4_1 = 4.402402014596e-07
alterparam pv_M4_2 = -7.444796563733e-07
alterparam pv_M4_3 = -4.838200260144e-07
reset
op
echo MCS 172
print v(inn)
print v(inp)
print v(out)
alterparam pv_M1_0 = 6.666411274636e-07
alterparam pv_M1_1 = 6.117980854004e-07
alterparam pv_M1_2 = -4.394132754843e-07
alterparam pv_M2_0 = -9.249235553165e-07
alterparam pv_M2_1 = -7.371846301762e-08
alterparam pv_M2_2 = -1.129861804549e-06
alterparam pv_M3_0 = -7.144778096951e-07
alterparam pv_M3_1 = -2.741992501332e-07
alterparam pv_M3_2 = -1.118149533833e-07
alterparam pv_M3_3 = -3.926070477926e-07
alterparam pv_M4_0 = -1.027743654198e-07
alterparam pv_M4_1 = 9.772500825658e-07
alterparam pv_M4_2 = 4.434451617096e-07
alterparam pv_M4_3 = 9.752602393658e-07
reset
op
echo MCS 173
print v(inn)
print v(inp)
print v(out)
alterparam pv_M1_0 = 6.335884639288e-07
alterparam pv_M1_1 = 1.640358112039e-07
alterparam pv_M1_2 = -8.583146893080e-07
alterparam pv_M2_0 = -9.447562358203e-07
alterparam pv_M2_1 = -1.455599004348e-08
alterparam pv_M2_2 = -2.889292150664e-07
alterparam pv_M3_0 = -6.608217614776e-07
alterparam pv_M3_1 = 2.897049101003e-07
alterparam pv_M3_2 = 8.655546876607e-07
alterparam pv_M3_3 = -4.814512230631e-08
alterparam pv_M4_0 = 6.069490600628e-08
alterparam pv_M4_1 = -3.867625672451e-07
alterparam pv_M4_2 = -4.864476808173e-07
alterparam pv_M4_3 = 1.395583446064e-06
reset
op
echo MCS 174
print v(inn)
print v(inp)
print v(out)
alterparam pv_M1_0 = -8.884167512290e-07
alterparam pv_M1_1 = -1.140030541250e-07
alterparam pv_M1_2 = -3.161758307537e-07
alterparam pv_M2_0 = -7.770511984757e-08
alterparam pv_M2_1 = 7.398694177604e-07
alterparam pv_M2_2 = 7.026962975195e-07
alterparam pv_M3_0 = -9.907414359790e-08
alterparam pv_M3_1 = 7.944314314422e-07
alterparam pv_M3_2 = -5.420307036332e-07
alterparam pv_M3_3 = 2.515016979524e-07
alterparam pv_M4_0 = 1.258305020532e-06
alterparam pv_M4_1 = -4.084163486164e-07
alterparam pv_M4_2 = 1.450399096916e-07
alterparam pv_M4_3 = 1.059656034196e-06
reset
op
echo MCS 175
print v(inn)
print v(inp)
print v(out)
alterparam pv_M1_0 = -5.957215907849e-07
alterparam pv_M1_1 = 4.548474661212e-08
alterparam pv_M1_2 = -2.225974787116e-07
alterparam pv_M2_0 = -7.897980372452e-07
alterparam pv_M2_1 = 2.858557720991e-07
alterparam pv_M2_2 = -5.968893818731e-07
alterparam pv_M3_0 = 1.170795199743e-06
alterparam pv_M3_1 = 1.460966874604e-08
alterparam pv_M3_2 = -1.485981680170e-07
alterparam pv_M3_3 = 2.890072530348e-08
alterparam pv_M4_0 = 7.268165448580e-08
alterparam pv_M4_1 = -1.408728004710e-07
alterparam pv_M4_2 = 4.046667412736e-08
alterparam pv_M4_3 = -4.064531515332e-07
reset
op
echo MCS 176
print v(inn)
print v(inp)
print v(out)
alterparam pv_M1_0 = -3.531570578175e-07
alterparam pv_M1_1 = 3.726760392900e-07
alterparam pv_M1_2 = -1.510627796192e-06
alterparam pv_M2_0 = -5.653199912539e-07
alterparam pv_M2_1 = 6.049443195016e-09
alterparam pv_M2_2 = 2.420995416060e-07
alterparam pv_M3_0 = -2.761545344206e-07
alterparam pv_M3_1 = 9.632494492759e-08
alterparam pv_M3_2 = -2.471088588063e-07
alterparam pv_M3_3 = -1.315723180372e-06
alterparam pv_M4_0 = 6.650133140316e-07
alterparam pv_M4_1 = 1.895017860354e-07
alterparam pv_M4_2 = -6.769536423566e-07
alterparam pv_M4_3 = 1.042964791796e-06
reset
op
echo MCS 177
print v(inn)
print v(inp)
print v(out)
alterparam pv_M1_0 = 4.790609499124e-07
alterparam pv_M1_1 = -4.422984472993e-07
alterparam pv_M1_2 = 7.824608389797e-07
alterparam pv_M2_0 = 3.811502338536e-07
alterparam pv_M2_1 = 5.861029723170e-07
alterparam pv_M2_2 = -4.255324436899e-07
alterparam pv_M3_0 = -3.935993133260e-07
alterparam pv_M3_1 = -5.815699782756e-07
alterparam pv_M3_2 = -3.825861167170e-07
alterparam pv_M3_3 = -1.635600465493e-06
alterparam pv_M4_0 = 7.663383388905e-07
alterparam pv_M4_1 = -8.347029208519e-07
alterparam pv_M4_2 = 4.028474973289e-07
alterparam pv_M4_3 = -9.179796732406e-07
reset
op
echo MCS 178
print v(inn)
print v(inp)
print v(out)
alterparam pv_M1_0 = 8.259489169742e-08
alterparam pv_M1_1 = -8.431199575314e-07
alterparam pv_M1_2 = -1.405656246238e-08
alterparam pv_M2_0 = -1.131156059408e-06
alterparam pv_M2_1 = -4.185513921095e-07
alterparam pv_M2_2 = 4.664364420563e-07
alterparam pv_M3_0 = 1.512474733624e-07
alterparam pv_M3_1 = 1.209477184546e-07
alterparam pv_M3_2 = -6.070058656949e-07
alterparam pv_M3_3 = -1.553182823847e-06
alterparam pv_M4_0 = -6.314645649880e-07
alterparam pv_M4_1 = -3.612967406230e-07
alterparam pv_M4_2 = 1.045986988923e-06
alterparam pv_M4_3 = 4.027142151242e-07
reset
op
echo MCS 179
print v(inn)
print v(inp)
print v(out)
alterparam pv_M1_0 = 2.237726853062e-07
alterparam pv_M1_1 = -4.114395448008e-07
alterparam pv_M1_2 = -5.156643756737e-07
alterparam pv_M2_0 = 4.529879846565e-07
alterparam pv_M2_1 = -2.630799603517e-07
alterparam pv_M2_2 = -2.382203614653e-07
alterparam pv_M3_0 = 1.356127923885e-06
alterparam pv_M3_1 = -6.942511295308e-07
alterparam pv_M3_2 = -1.991253067505e-07
alterparam pv_M3_3 = -1.765574593250e-07
alterparam pv_M4_0 = -4.605620618157e-07
alterparam pv_M4_1 = -9.981282985874e-07
alterparam pv_M4_2 = 8.996877989989e-07
alterparam pv_M4_3 = -9.987503515112e-07
reset
op
echo MCS 180
print v(inn)
print v(inp)
print v(out)
alterparam pv_M1_0 = -6.417802893090e-07
alterparam pv_M1_1 = 1.812068767419e-07
alterparam pv_M1_2 = -8.794539497625e-07
alterparam pv_M2_0 = -1.101670609117e-07
alterparam pv_M2_1 = -1.814401028108e-07
alterparam pv_M2_2 = -1.674075626447e-07
alterparam pv_M3_0 = -9.904212839370e-08
alterparam pv_M3_1 = -9.959038198492e-07
alterparam pv_M3_2 = -3.885572941835e-07
alterparam pv_M3_3 = 9.082877897812e-07
alterparam pv_M4_0 = 8.230323697783e-07
alterparam pv_M4_1 = -4.106724019618e-07
alterparam pv_M4_2 = 7.671372164333e-07
alterparam pv_M4_3 = -6.645850515022e-07
reset
op
echo MCS 181
print v(inn)
print v(inp)
print v(out)
alterparam pv_M1_0 = -9.644643008285e-07
alterparam pv_M1_1 = -1.426420432913e-06
alterparam pv_M1_2 = -7.870086039714e-07
alterparam pv_M2_0 = 3.251826099194e-07
alterparam pv_M2_1 = -2.301971491233e-07
alterparam pv_M2_2 = 1.174952756250e-06
alterparam pv_M3_0 = 5.935711588183e-07
alterparam pv_M3_1 = -2.504676368826e-07
alterparam pv_M3_2 = -1.578831910686e-07
alterparam pv_M3_3 = -1.526726684979e-07
alterparam pv_M4_0 = 7.064745581265e-07
alterparam pv_M4_1 = -2.716632448466e-07
alterparam pv_M4_2 = -1.025455740836e-08
alterparam pv_M4_3 = -5.200376520524e-07
reset
op
echo MCS 182
print v(inn)
print v(inp)
print v(out)
alterparam pv_M1_0 = 9.183579351128e-07
alterparam pv_M1_1 = -2.468582195077e-07
alterparam pv_M1_2 = -4.573542549436e-07
alterparam pv_M2_0 = -1.074901832188e-06
alterparam pv_M2_1 = 6.832401376393e-07
alterparam pv_M2_2 = -4.183968064555e-07
alterparam pv_M3_0 = -4.977200325963e-08
alterparam pv_M3_1 = -2.902296588058e-07
alterparam pv_M3_2 = -1.318883469040e-07
alterparam pv_M3_3 = -1.401873209776e-06
alterparam pv_M4_0 = -5.547812530783e-07
alterparam pv_M4_1 = -7.662289981437e-07
alterparam pv_M4_2 = 1.540358145447e-06
alterparam pv_M4_3 = 9.523780320612e-07
reset
op
echo MCS 183
print v(inn)
print v(inp)
print v(out)
alterparam pv_M1_0 = 3.097670574832e-07
alterparam pv_M1_1 = 1.758407518510e-06
alterparam pv_M1_2 = 9.032033017849e-07
alterparam pv_M2_0 = -9.508630513134e-07
alterparam pv_M2_1 = -9.087911096905e-07
alterparam pv_M2_2 = 1.894091448966e-07
alterparam pv_M3_0 = -4.905519229855e-08
alterparam pv_M3_1 = 1.495370390100e-07
alterparam pv_M3_2 = -5.833144184168e-07
alterparam pv_M3_3 = 1.304968535859e-06
alterparam pv_M4_0 = -2.482747204576e-07
alterparam pv_M4_1 = 7.921224756196e-07
alterparam pv_M4_2 = 1.031945675314e-06
alterparam pv_M4_3 = -4.138239177650e-07
reset
op
echo MCS 184
print v(inn)
print v(inp)
print v(out)
alterparam pv_M1_0 = 4.075630020004e-07
alterparam pv_M1_1 = 1.126405837469e-06
alterparam pv_M1_2 = 1.031135172151e-06
alterparam pv_M2_0 = 5.315808711925e-07
alterparam pv_M2_1 = 3.109186307874e-07
alterparam pv_M2_2 = 5.575568694932e-08
alterparam pv_M3_0 = 8.971536862885e-07
alterparam pv_M3_1 = 4.122861204919e-07
alterparam pv_M3_2 = 8.788720171441e-08
alterparam pv_M3_3 = -3.342543319420e-07
alterparam pv_M4_0 = -9.564730144443e-07
alterparam pv_M4_1 = -1.226997750675e-07
alterparam pv_M4_2 = 1.318370454227e-06
alterparam pv_M4_3 = -3.419653701141e-07
reset
op
echo MCS 185
print v(inn)
print v(inp)
print v(out)
alterparam pv_M1_0 = -4.534130043269e-07
alterparam pv_M1_1 = -1.701737914624e-07
alterparam pv_M1_2 = -1.505209572291e-07
alterparam pv_M2_0 = -3.953964137957e-07
alterparam pv_M2_1 = 4.548376806533e-07
alterparam pv_M2_2 = 2.303706028937e-07
alterparam pv_M3_0 = 8.364159845201e-07
alterparam pv_M3_1 = 4.253320619370e-07
alterparam pv_M3_2 = 1.318643628002e-07
alterparam pv_M3_3 = -1.487092415444e-06
alterparam pv_M4_0 = 1.394042130989e-07
alterparam pv_M4_1 = -4.618324841038e-07
alterparam pv_M4_2 = 7.620686765856e-07
alterparam pv_M4_3 = 5.192986564944e-08
reset
op
echo MCS 186
print v(inn)
print v(inp)
print v(out)
alterparam pv_M1_0 = -5.392522412157e-07
alterparam pv_M1_1 = -3.841291007631e-07
alterparam pv_M1_2 = -8.495796235225e-07
alterparam pv_M2_0 = -3.871742888400e-07
alterparam pv_M2_1 = 2.228707399325e-07
alterparam pv_M2_2 = 8.335541381591e-07
alterparam pv_M3_0 = 3.675936718240e-07
alterparam pv_M3_1 = 5.725413993121e-07
alterparam pv_M3_2 = 6.301066384762e-07
alterparam pv_M3_3 = -2.288385103419e-07
alterparam pv_M4_0 = 1.027529293864e-06
alterparam pv_M4_1 = -9.558010300379e-07
alterparam pv_M4_2 = 8.724455662457e-08
alterparam pv_M4_3 = -3.717651135711e-07
reset
op
echo MCS 187
print v(inn)
print v(inp)
print v(out)
alterparam pv_M1_0 = -1.389779798251e-06
alterparam pv_M1_1 = 1.173086375993e-06
alterparam pv_M1_2 = -1.412581168976e-06
alterparam pv_M2_0 = 4.874442328983e-07
alterparam pv_M2_1 = 1.267966233028e-06
alterparam pv_M2_2 = -1.436299451179e-07
alterparam pv_M3_0 = -8.158007823922e-08
alterparam pv_M3_1 = -1.342642425369e-06
alterparam pv_M3_2 = -1.766402240101e-07
alterparam pv_M3_3 = 1.025954198689e-06
alterparam pv_M4_0 = -3.691942013982e-07
alterparam pv_M4_1 = -6.890041194359e-07
alterparam pv_M4_2 = -1.637482500219e-06
alterparam pv_M4_3 = 9.091120507862e-07
reset
op
echo MCS 188
print v(inn)
print v(inp)
print v(out)
alterparam pv_M1_0 = 2.911783707888e-07
alterparam pv_M1_1 = -2.135600767820e-07
alterparam pv_M1_2 = 7.373595413589e-07
alterparam pv_M2_0 = -3.752483986960e-07
alterparam pv_M2_1 = -2.361867750623e-07
alterparam pv_M2_2 = 1.501909580593e-06
alterparam pv_M3_0 = -6.337555368338e-07
alterparam pv_M3_1 = 2.052959916282e-07
alterparam pv_M3_2 = 1.580549749076e-07
alterparam pv_M3_3 = 6.890192794725e-08
alterparam pv_M4_0 = 4.436211504252e-09
alterparam pv_M4_1 = -9.239486449096e-07
alterparam pv_M4_2 = -9.722782886962e-08
alterparam pv_M4_3 = -1.714528631063e-07
reset
op
echo MCS 189
print v(inn)
print v(inp)
print v(out)
alterparam pv_M1_0 = -4.730010089106e-07
alterparam pv_M1_1 = -5.894017643459e-07
alterparam pv_M1_2 = -7.083246024147e-07
alterparam pv_M2_0 = -5.723512376542e-07
alterparam pv_M2_1 = 2.892745317444e-07
alterparam pv_M2_2 = 2.577845666453e-08
alterparam pv_M3_0 = 1.170613503531e-06
alterparam pv_M3_1 = 4.266207783181e-07
alterparam pv_M3_2 = -4.207699356225e-07
alterparam pv_M3_3 = -3.812123276994e-07
alterparam pv_M4_0 = -1.223095423570e-07
alterparam pv_M4_1 = -2.475023132321e-07
alterparam pv_M4_2 = 2.612078482205e-09
alterparam pv_M4_3 = 1.372633308028e-06
reset
op
echo MCS 190
print v(inn)
print v(inp)
print v(out)
alterparam pv_M1_0 = -1.074651871445e-07
alterparam pv_M1_1 = 9.333596661286e-08
alterparam pv_M1_2 = -8.426144804660e-07
alterparam pv_M2_0 = -1.061046682110e-06
alterparam pv_M2_1 = -9.591309412741e-08
alterparam pv_M2_2 = -2.950656515842e-07
alterparam pv_M3_0 = 1.426264209372e-07
alterparam pv_M3_1 = 9.595354286556e-07
alterparam pv_M3_2 = -3.609528839353e-07
alterparam pv_M3_3 = -4.840771004843e-07
alterparam pv_M4_0 = 6.919026860342e-07
alterparam pv_M4_1 = -3.080718667675e-07
alterparam pv_M4_2 = 4.066922871129e-08
alterparam pv_M4_3 = -7.472669746135e-08
reset
op
echo MCS 191
print v(inn)
print v(inp)
print v(out)
alterparam pv_M1_0 = 1.328784356100e-06
alterparam pv_M1_1 = -1.190157028361e-06
alterparam pv_M1_2 = -5.804680117644e-07
alterparam pv_M2_0 = 4.601798600598e-07
alterparam pv_M2_1 = 8.203118162575e-07
alterparam pv_M2_2 = -7.276613302066e-07
alterparam pv_M3_0 = 8.335664506815e-07
alterparam pv_M3_1 = -3.330725120381e-07
alterparam pv_M3_2 = -5.135443609306e-07
alterparam pv_M3_3 = -4.455656922894e-07
alterparam pv_M4_0 = 2.501958526292e-07
alterparam pv_M4_1 = 3.426683813204e-07
alterparam pv_M4_2 = -6.185625426056e-07
alterparam pv_M4_3 = 1.456384193528e-07
reset
op
echo MCS 192
print v(inn)
print v(inp)
print v(out)
alterparam pv_M1_0 = -2.701795632392e-07
alterparam pv_M1_1 = -8.434209715122e-07
alterparam pv_M1_2 = 1.196273599865e-06
alterparam pv_M2_0 = -6.841393528382e-07
alterparam pv_M2_1 = 7.250708087038e-08
alterparam pv_M2_2 = -8.236829662534e-07
alterparam pv_M3_0 = -3.050414870077e-07
alterparam pv_M3_1 = 6.425616562108e-08
alterparam pv_M3_2 = 1.141238486001e-07
alterparam pv_M3_3 = -7.239052370065e-07
alterparam pv_M4_0 = -8.476306345143e-08
alterparam pv_M4_1 = 2.474492314700e-07
alterparam pv_M4_2 = 1.049472149848e-06
alterparam pv_M4_3 = 5.643789196753e-07
reset
op
echo MCS 193
print v(inn)
print v(inp)
print v(out)
alterparam pv_M1_0 = 7.586421632732e-07
alterparam pv_M1_1 = 4.476157282595e-07
alterparam pv_M1_2 = -4.717212535647e-07
alterparam pv_M2_0 = -2.321907901438e-07
alterparam pv_M2_1 = 6.410138096345e-07
alterparam pv_M2_2 = -4.860836723465e-07
alterparam pv_M3_0 = -7.929141123738e-07
alterparam pv_M3_1 = -3.095531947415e-08
alterparam pv_M3_2 = -1.285516849733e-06
alterparam pv_M3_3 = -5.532553256209e-07
alterparam pv_M4_0 = -8.057823825254e-07
alterparam pv_M4_1 = -2.916789856300e-07
alterparam pv_M4_2 = 9.279659039650e-07
alterparam pv_M4_3 = 1.639911396016e-06
reset
op
echo MCS 194
print v(inn)
print v(inp)
print v(out)
alterparam pv_M1_0 = 4.193502518151e-07
alterparam pv_M1_1 = -6.792675015346e-07
alterparam pv_M1_2 = 5.169661975267e-07
alterparam pv_M2_0 = 2.973326510387e-07
alterparam pv_M2_1 = -4.259386114257e-07
alterparam pv_M2_2 = 6.230155979558e-07
alterparam pv_M3_0 = -3.419311917862e-07
alterparam pv_M3_1 = -4.097292536579e-07
alterparam pv_M3_2 = 4.056736028238e-08
alterparam pv_M3_3 = 4.846951317332e-07
alterparam pv_M4_0 = -2.604401786295e-07
alterparam pv_M4_1 = 2.511786573352e-07
alterparam pv_M4_2 = -1.293597167550e-06
alterparam pv_M4_3 = 2.066724318038e-07
reset
op
echo MCS 195
print v(inn)
print v(inp)
print v(out)
alterparam pv_M1_0 = -3.383084027442e-07
alterparam pv_M1_1 = -3.697603988295e-07
alterparam pv_M1_2 = -1.786003058168e-06
alterparam pv_M2_0 = -1.024740892712e-06
alterparam pv_M2_1 = -1.234287527045e-06
alterparam pv_M2_2 = 4.281204742119e-07
alterparam pv_M3_0 = -6.519039783349e-07
alterparam pv_M3_1 = 1.932659499840e-07
alterparam pv_M3_2 = 4.659192467321e-07
alterparam pv_M3_3 = -3.863742159843e-07
alterparam pv_M4_0 = -7.265229268732e-07
alterparam pv_M4_1 = 8.559599095912e-07
alterparam pv_M4_2 = 1.852205236201e-07
alterparam pv_M4_3 = -8.716388587231e-07
reset
op
echo MCS 196
print v(inn)
print v(inp)
print v(out)
alterparam pv_M1_0 = 3.397048687142e-07
alterparam pv_M1_1 = -4.693908090936e-07
alterparam pv_M1_2 = 3.287281890827e-07
alterparam pv_M2_0 = 5.841941306990e-07
alterparam pv_M2_1 = -5.776629126333e-07
alterparam pv_M2_2 = 3.476422724292e-07
alterparam pv_M3_0 = -2.129416769494e-06
alterparam pv_M3_1 = 3.868779605166e-07
alterparam pv_M3_2 = -1.385969677723e-06
alterparam pv_M3_3 = 1.785836957720e-06
alterparam pv_M4_0 = 2.504306613367e-07
alterparam pv_M4_1 = -4.338435816595e-07
alterparam pv_M4_2 = 8.013501390163e-07
alterparam pv_M4_3 = -5.546864741596e-07
reset
op
echo MCS 197
print v(inn)
print v(inp)
print v(out)
alterparam pv_M1_0 = 8.426955673576e-08
alterparam pv_M1_1 = -2.014593782372e-07
alterparam pv_M1_2 = 8.327176942315e-10
alterparam pv_M2_0 = -3.956578388402e-07
alterparam pv_M2_1 = 3.098116239168e-07
alterparam pv_M2_2 = -5.231528280207e-07
alterparam pv_M3_0 = 7.956405018392e-08
alterparam pv_M3_1 = 4.444119984903e-07
alterparam pv_M3_2 = -4.210851019022e-07
alterparam pv_M3_3 = 5.908758689025e-07
alterparam pv_M4_0 = 3.434582823271e-07
alterparam pv_M4_1 = -2.089665194127e-07
alterparam pv_M4_2 = -3.634496782391e-07
alterparam pv_M4_3 = -3.450321393243e-08
reset
op
echo MCS 198
print v(inn)
print v(inp)
print v(out)
alterparam pv_M1_0 = -3.202120995654e-07
alterparam pv_M1_1 = -3.633332103438e-07
alterparam pv_M1_2 = -9.382705051044e-08
alterparam pv_M2_0 = -1.500749564917e-07
alterparam pv_M2_1 = 7.550291212874e-08
alterparam pv_M2_2 = 1.003941005712e-06
alterparam pv_M3_0 = 6.447198632637e-07
alterparam pv_M3_1 = 6.007296266570e-07
alterparam pv_M3_2 = 3.657976978366e-07
alterparam pv_M3_3 = -4.269429449515e-07
alterparam pv_M4_0 = -7.500009425918e-07
alterparam pv_M4_1 = -1.609117397254e-07
alterparam pv_M4_2 = 8.387407072420e-07
alterparam pv_M4_3 = 8.479602535551e-07
reset
op
echo MCS 199
print v(inn)
print v(inp)
print v(out)
alterparam pv_M1_0 = -1.030976915769e-06
alterparam pv_M1_1 = -1.254510740200e-06
alterparam pv_M1_2 = 1.184305024599e-06
alterparam pv_M2_0 = 1.007636713327e-06
alterparam pv_M2_1 = -4.430461021363e-07
alterparam pv_M2_2 = -5.460113281568e-08
alterparam pv_M3_0 = 3.534745248859e-08
alterparam pv_M3_1 = 7.800695350822e-07
alterparam pv_M3_2 = -3.450513907350e-07
alterparam pv_M3_3 = 4.184588292708e-07
alterparam pv_M4_0 = 1.935904320087e-07
alterparam pv_M4_1 = 2.125784253166e-07
alterparam pv_M4_2 = 7.453022654521e-07
alterparam pv_M4_3 = 1.037034018499e-07
reset
op
echo MCS 200
print v(inn)
print v(inp)
print v(out)
alterparam pv_M1_0 = -9.060313835215e-07
alterparam pv_M1_1 = 6.380964695579e-07
alterparam pv_M1_2 = -3.443948490276e-07
alterparam pv_M2_0 = 6.348487662328e-07
alterparam pv_M2_1 = 1.872059267717e-07
alterparam pv_M2_2 = -6.915694022803e-07
alterparam pv_M3_0 = 1.803477489591e-07
alterparam pv_M3_1 = -4.490372865285e-07
alterparam pv_M3_2 = 1.910722373736e-07
alterparam pv_M3_3 = -2.858780773038e-07
alterparam pv_M4_0 = 7.142135648806e-07
alterparam pv_M4_1 = -5.032669514577e-07
alterparam pv_M4_2 = -2.599555631922e-07
alterparam pv_M4_3 = -4.948911243434e-07
reset
op
echo MCS 201
print v(inn)
print v(inp)
print v(out)
quit
.endc
.end
