* m1 bench
.include "C:\pdk\sky130_fd_pr\cells\nfet_01v8\sky130_fd_pr__nfet_01v8__tt.pm3.spice"
.include "C:\pdk\sky130_fd_pr\cells\nfet_01v8\sky130_fd_pr__nfet_01v8__mismatch.corner.spice"
.option reltol=1e-4

Ia 0 ga DC 10u
Ib 0 gb DC 10u
XA ga ga 0 0 sky130_fd_pr__nfet_01v8 w=5e-6 l=1e-6
XB gb gb 0 0 sky130_fd_pr__nfet_01v8 w=5e-6 l=1e-6
.control
op
print v(ga) v(gb) v(ga)-v(gb)
showmod m.xa.msky130_fd_pr__nfet_01v8 : vth0 toxe voff
showmod m.xb.msky130_fd_pr__nfet_01v8 : vth0 toxe voff
quit
.endc
.end
