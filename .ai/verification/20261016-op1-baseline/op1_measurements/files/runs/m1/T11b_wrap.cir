* m1 bench
.include "C:\pdk\sky130_fd_pr\cells\nfet_01v8\sky130_fd_pr__nfet_01v8__tt.pm3.spice"
.include "C:\pdk\sky130_fd_pr\cells\nfet_01v8\sky130_fd_pr__nfet_01v8__mismatch.corner.spice"
.option scale=1u

.subckt mmv d g s b params: v0=0
.param sky130_fd_pr__nfet_01v8__vth0_slope_spectre={v0}
X1 d g s b sky130_fd_pr__nfet_01v8 w=5 l=1
.ends
Ia 0 ga DC 10u
Ib 0 gb DC 10u
XA ga ga 0 0 mmv v0=1
XB gb gb 0 0 mmv v0=-1
.control
op
print v(ga) v(gb) v(ga)-v(gb)
showmod m.xa.x1.msky130_fd_pr__nfet_01v8 : vth0
showmod m.xb.x1.msky130_fd_pr__nfet_01v8 : vth0
print @m.xa.x1.msky130_fd_pr__nfet_01v8[vth] @m.xb.x1.msky130_fd_pr__nfet_01v8[vth]
quit
.endc
.end
