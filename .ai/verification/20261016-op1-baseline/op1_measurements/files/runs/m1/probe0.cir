* probe0: syntax check -- global agauss redefinition, option seed, showmod
.include "C:\pdk\sky130_fd_pr\cells\nfet_01v8\sky130_fd_pr__nfet_01v8__tt.pm3.spice"
.include "C:\pdk\sky130_fd_pr\cells\nfet_01v8\sky130_fd_pr__nfet_01v8__mismatch.corner.spice"
.param sky130_fd_pr__nfet_01v8__vth0_slope_spectre = agauss(0,1,1)
.option scale=1u seed=7
Ia 0 ga DC 10u
Ib 0 gb DC 10u
XA ga ga 0 0 sky130_fd_pr__nfet_01v8 w=5 l=1
XB gb gb 0 0 sky130_fd_pr__nfet_01v8 w=5 l=1
.control
op
print v(ga) v(gb) v(ga)-v(gb)
print @m.xa.msky130_fd_pr__nfet_01v8[vth] @m.xb.msky130_fd_pr__nfet_01v8[vth]
showmod m.xa.msky130_fd_pr__nfet_01v8 : vth0 lmin lmax
showmod m.xb.msky130_fd_pr__nfet_01v8 : vth0
quit
.endc
.end
