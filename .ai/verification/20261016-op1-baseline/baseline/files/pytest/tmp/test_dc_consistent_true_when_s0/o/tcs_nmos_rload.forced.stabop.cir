* spice_oracle: tcs_nmos_rload bias=forced
.include "C:/pdk/sky130_fd_pr/cells/nfet_01v8/sky130_fd_pr__nfet_01v8__tt.pm3.spice"
.include "C:/pdk/sky130_fd_pr/cells/nfet_01v8/sky130_fd_pr__nfet_01v8__mismatch.corner.spice"
.include "C:/pdk/sky130_fd_pr/models/parameters/lod.spice"
.include "C:/pdk/sky130_fd_pr/cells/pfet_01v8/sky130_fd_pr__pfet_01v8__tt.pm3.spice"
.include "C:/pdk/sky130_fd_pr/cells/pfet_01v8/sky130_fd_pr__pfet_01v8__mismatch.corner.spice"
.temp 27
.option gmin=1e-15 reltol=1e-4 abstol=1e-14 vntol=1e-7
Vrail_vdd vdd 0 DC 1.8
Vrail_vsp vsp 0 DC 1.5
XM1 nout nin 0 0 sky130_fd_pr__nfet_01v8 l=5e-07 w=2e-06 m=2 ad=1e-12 as=1e-12 pd=4e-06 ps=4e-06
XMP1 pout pb vsp vdd sky130_fd_pr__pfet_01v8 l=5e-07 w=2e-06 m=3 ad=1e-12 as=1e-12 pd=4e-06 ps=4e-06
Rp_RL vdd nout 100000
Cp_CL nout 0 1e-12
Rp_RP pout 0 10000
Vdc_nin dcs_nin 0 DC 0.7
Ldc_nin dcs_nin nin 1e+12
Cac_nin nin acs_nin 1
Vac_nin acs_nin 0 DC 0 AC 1
Vbias_pb pb 0 DC 0.3
Vhold_nout hs_nout 0 DC 0.9275921
Lhold_nout hs_nout nout 1e+12
Vhold_pout hs_pout 0 DC 0.1647339
Lhold_pout hs_pout pout 1e+12
.control
set noaskquit
op
echo OPSTART
print i(ldc_nin)
print i(lhold_nout)
print i(lhold_pout)
print v(nin)
print v(nout)
print v(pout)
echo OPEND
quit
.endc
.end
