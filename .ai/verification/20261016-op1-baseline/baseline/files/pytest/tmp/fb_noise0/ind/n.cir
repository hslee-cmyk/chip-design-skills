* independent C10 reference
.include "C:/pdk/sky130_fd_pr/cells/nfet_01v8/sky130_fd_pr__nfet_01v8__tt.pm3.spice"
.include "C:/pdk/sky130_fd_pr/cells/nfet_01v8/sky130_fd_pr__nfet_01v8__mismatch.corner.spice"
.include "C:/pdk/sky130_fd_pr/models/parameters/lod.spice"
.include "C:/pdk/sky130_fd_pr/cells/pfet_01v8/sky130_fd_pr__pfet_01v8__tt.pm3.spice"
.include "C:/pdk/sky130_fd_pr/cells/pfet_01v8/sky130_fd_pr__pfet_01v8__mismatch.corner.spice"
.temp 27.0
.option gmin=1e-15 reltol=1e-4 abstol=1e-14 vntol=1e-7
Vdd vdd 0 DC 1.8
Vb vb 0 DC 0.7 AC 1
Lb vb nin 1e+20
RL vdd nout 100000.0
CL nout 0 1e-11
Rf nout nin 1000000.0
Cin nin 0 1e-12
XM1_0 nout nin 0 0 sky130_fd_pr__nfet_01v8 l=5e-07 w=2e-06
XM1_1 nout nin 0 0 sky130_fd_pr__nfet_01v8 l=5e-07 w=2e-06
.control
set noaskquit
noise v(nout) Vb dec 100 1.0 1000000000000000.0
setplot noise1
set wr_singlescale
wrdata ns.txt onoise_spectrum
quit
.endc
.end
