* spice_oracle: tdiff_fb bias=free
.include "C:/pdk/sky130_fd_pr/cells/nfet_01v8/sky130_fd_pr__nfet_01v8__tt.pm3.spice"
.include "C:/pdk/sky130_fd_pr/cells/nfet_01v8/sky130_fd_pr__nfet_01v8__mismatch.corner.spice"
.temp 27
.option gmin=1e-15 reltol=1e-4 abstol=1e-14 vntol=1e-7
Vrail_vdd vdd 0 DC 1.8
XMp op nip 0 0 sky130_fd_pr__nfet_01v8 l=5e-07 w=2e-06 m=2 ad=0 as=0 pd=0 ps=0
XMn on nin 0 0 sky130_fd_pr__nfet_01v8 l=5e-07 w=2e-06 m=2 ad=0 as=0 pd=0 ps=0
Rp_RLp vdd op 100000
Cp_CLp op 0 1e-11
Rp_Rfp op lbx_nip 1000000
Cp_Cinp lbx_nip 0 1e-11
Rp_RLn vdd on 100000
Cp_CLn on 0 1e-11
Rp_Rfn on lbx_nin 1000000
Cp_Cinn lbx_nin 0 1e-11
Vpz_nip nip 0 DC 0.7
Vpz_nin nin 0 DC 0.7
Vpz_lbx_nip lbx_nip 0 DC 0.7
Vpz_lbx_nin lbx_nin 0 DC 0.7
.control
set noaskquit
op
echo PZSTART
pz op 0 op 0 cur pol
print all
echo PZEND
quit
.endc
.end
