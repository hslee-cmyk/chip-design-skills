* spice_oracle: t5ota bias=free
.include "C:/pdk/sky130_fd_pr/cells/nfet_01v8/sky130_fd_pr__nfet_01v8__tt.pm3.spice"
.include "C:/pdk/sky130_fd_pr/cells/nfet_01v8/sky130_fd_pr__nfet_01v8__mismatch.corner.spice"
.include "C:/pdk/sky130_fd_pr/models/parameters/lod.spice"
.include "C:/pdk/sky130_fd_pr/cells/pfet_01v8/sky130_fd_pr__pfet_01v8__tt.pm3.spice"
.include "C:/pdk/sky130_fd_pr/cells/pfet_01v8/sky130_fd_pr__pfet_01v8__mismatch.corner.spice"
.temp 27
.option gmin=1e-15 reltol=1e-4 abstol=1e-14 vntol=1e-7
Vrail_vdd vdd 0 DC 1.8
XM1 d1 inp tail 0 sky130_fd_pr__nfet_01v8 l=1e-06 w=2e-06 m=2 ad=0 as=0 pd=0 ps=0
XM2 out inn tail 0 sky130_fd_pr__nfet_01v8 l=1e-06 w=2e-06 m=2 ad=0 as=0 pd=0 ps=0
XM3 d1 d1 vdd vdd sky130_fd_pr__pfet_01v8 l=1e-06 w=2e-06 m=2 ad=0 as=0 pd=0 ps=0
XM4 out d1 vdd vdd sky130_fd_pr__pfet_01v8 l=1e-06 w=2e-06 m=2 ad=0 as=0 pd=0 ps=0
Isrc_IT tail 0 DC 2e-05
Cp_CL out 0 1e-12
Vpz_inp inp 0 DC 0.9
Vpz_inn inn 0 DC 0.8959681
.control
set noaskquit
op
echo PZSTART
pz out 0 out 0 cur pol
print all
echo PZEND
quit
.endc
.end
