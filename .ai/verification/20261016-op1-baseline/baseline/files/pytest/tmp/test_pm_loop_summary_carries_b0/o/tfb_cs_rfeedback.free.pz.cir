* spice_oracle: tfb_cs_rfeedback bias=free
.include "C:/pdk/sky130_fd_pr/cells/nfet_01v8/sky130_fd_pr__nfet_01v8__tt.pm3.spice"
.include "C:/pdk/sky130_fd_pr/cells/nfet_01v8/sky130_fd_pr__nfet_01v8__mismatch.corner.spice"
.temp 27
.option gmin=1e-15 reltol=1e-4 abstol=1e-14 vntol=1e-7
Vrail_vdd vdd 0 DC 1.8
XM1 nout nin 0 0 sky130_fd_pr__nfet_01v8 l=5e-07 w=2e-06 m=2 ad=0 as=0 pd=0 ps=0
Rp_RL vdd nout 100000
Cp_CL nout 0 1e-11
Rp_Rf nout lbx_nin 1000000
Cp_Cin lbx_nin 0 1e-11
Vpz_nin nin 0 DC 0.7
Vpz_lbx_nin lbx_nin 0 DC 0.7
.control
set noaskquit
op
echo PZSTART
pz nout 0 nout 0 cur pol
print all
echo PZEND
quit
.endc
.end
