* spice_oracle: trc_lowpass_div bias=free
.include "C:/pdk/sky130_fd_pr/cells/nfet_01v8/sky130_fd_pr__nfet_01v8__tt.pm3.spice"
.include "C:/pdk/sky130_fd_pr/cells/nfet_01v8/sky130_fd_pr__nfet_01v8__mismatch.corner.spice"
.temp 27
.option gmin=1e-15 reltol=1e-4 abstol=1e-14 vntol=1e-7
Vrail_vdd vdd 0 DC 1.8
XMD ndio ndio 0 0 sky130_fd_pr__nfet_01v8 l=1e-06 w=1e-06 m=1 ad=5e-13 as=5e-13 pd=3e-06 ps=3e-06
Rp_Ra rin rout 2000
Rp_Rb rout 0 2000
Cp_C1 rout 0 1e-09
Rp_R1 vdd dmid 3000
Rp_R2 dmid 0 1000
Rp_Rd vdd ndio 100000
Vdc_rin dcs_rin 0 DC 0.6
Ldc_rin dcs_rin rin 1e+12
Cac_rin rin acs_rin 1
Vac_rin acs_rin 0 DC 0 AC 1
.control
set noaskquit
op
echo OPSTART
print @m.xmd.msky130_fd_pr__nfet_01v8[id]
print @m.xmd.msky130_fd_pr__nfet_01v8[gm]
print @m.xmd.msky130_fd_pr__nfet_01v8[gds]
print @m.xmd.msky130_fd_pr__nfet_01v8[vth]
print @m.xmd.msky130_fd_pr__nfet_01v8[vdsat]
print @m.xmd.msky130_fd_pr__nfet_01v8[vgs]
print @m.xmd.msky130_fd_pr__nfet_01v8[vds]
print @m.xmd.msky130_fd_pr__nfet_01v8[vbs]
print v(ndio)
print v(rin)
print v(rout)
print v(vdd)
print v(dmid)
print i(vrail_vdd)
echo OPEND
ac dec 40 0.01 1e+10
let hout = v(rout)
set wr_singlescale
wrdata t.free.ac.txt hout
quit
.endc
.end
