* spice_oracle: tcs_nmos_rload bias=free
.include "C:/pdk/sky130_fd_pr/cells/nfet_01v8/sky130_fd_pr__nfet_01v8__tt.pm3.spice"
.include "C:/pdk/sky130_fd_pr/cells/nfet_01v8/sky130_fd_pr__nfet_01v8__mismatch.corner.spice"
.include "C:/pdk/sky130_fd_pr/models/parameters/lod.spice"
.include "C:/pdk/sky130_fd_pr/cells/pfet_01v8/sky130_fd_pr__pfet_01v8__tt.pm3.spice"
.include "C:/pdk/sky130_fd_pr/cells/pfet_01v8/sky130_fd_pr__pfet_01v8__mismatch.corner.spice"
.temp 27
.option gmin=1e-15 reltol=1e-4 abstol=1e-14 vntol=1e-7
Vrail_vdd vdd 0 DC 1.8
Vrail_vsp vsp 0 DC 1.5
XM1 nout nin 0 0 sky130_fd_pr__nfet_01v8 l=5e-07 w=2e-06 m=2 ad=1e-12 as=1e-12 pd=4e-06 ps=4e-06
XMP1 pout pb vsp vdd sky130_fd_pr__pfet_01v8 l=5e-07 w=2e-06 m=3 ad=1e-12 as=1e-12 pd=4e-06 ps=4e-06
Rp_RL vdd nout 100000
Cp_CL nout 0 1e-12
Rp_RP pout 0 10000
Vbias_pb pb 0 DC 0.3
Ecl_nin nin ecl_nin nout 0 1
Vcl_nin ecl_nin 0 PULSE(-0.2275922 -0.2017272742 7.144871101e-09 7.144871101e-09 7.144871101e-09 7.144871101e-09 5.958695583e-07)
.save v(nin)
.control
set noaskquit
set numdgt=8
set wr_singlescale
let sw_tke = 2.85794844e-08
let sw_w = 4.489254912e-08
let sw_k = 6
let sw_rt = 0.0001
let sw_fl0 = 7.01e-05
let sw_u = 5e-09
let sw_j = 0
let sw_m1 = 0
let sw_p1 = 0
let sw_p2 = 0
let sw_fin = 0
let sw_kind = 0
stop when time > 7.347203353e-08
tran 2.003065434e-10 2.979347791e-07 0 2.003065434e-10
while sw_fin = 0
  let sw_j = sw_j + 1
  let hst = v(nin)
  let sw_lo = sw_tke + (sw_j - 1) * sw_w
  let sw_hi = sw_tke + sw_j * sw_w
  let sw_tl = time[length(time) - 1]
  if sw_tl >= sw_hi * (1 - 2 * sw_u)
    let sw_m = maximum(abs(hst - (hst[0])) * (time >= sw_lo) * (time <= sw_hi))
    echo STABWIN $&sw_j $&sw_m
    if sw_j = 1
      let sw_m1 = sw_m
    end
    let sw_fl = sw_fl0 + sw_u * maximum(abs(hst))
    let sw_up = (sw_m * (1 - sw_rt) >= sw_p1 * (1 + sw_rt) + sw_fl)
    let sw_dn = (sw_p1 * (1 - sw_rt) >= sw_m * (1 + sw_rt) + sw_fl)
    let sw_up0 = (sw_p1 * (1 - sw_rt) >= sw_p2 * (1 + sw_rt) + sw_fl)
    let sw_dn0 = (sw_p2 * (1 - sw_rt) >= sw_p1 * (1 + sw_rt) + sw_fl)
    let sw_upf = (sw_m * (1 - sw_rt) >= sw_m1 * (1 + sw_rt) + sw_fl)
    let sw_ab1 = (sw_m * (1 - sw_rt) >= sw_fl)
    let sw_ab0 = (sw_p1 * (1 - sw_rt) >= sw_fl)
    let sw_fl1 = sw_ab1 * (1 - sw_dn)
    let sw_fl0f = sw_ab0 * (1 - sw_dn0)
    let sw_gr = sw_up0 * sw_up * sw_upf
    let sw_lc = sw_fl0f * sw_fl1
    if sw_j >= 3
      if sw_gr >= 1
        let sw_fin = 1
        let sw_kind = 1
      end
      if sw_lc >= 1
        let sw_fin = 1
        let sw_kind = 2
      end
    end
    if sw_fin = 0
      if sw_j >= sw_k
        let sw_fin = 2
      else
        let sw_p2 = sw_p1
        let sw_p1 = sw_m
        let sw_nb = sw_tke + (sw_j + 1) * sw_w
        delete all
        if sw_k >= sw_j + 2
          stop when time > $&sw_nb
        end
        resume
      end
    end
  else
    let sw_fin = 3
  end
end
echo STABEND $&sw_j $&sw_fin $&sw_kind
let hst = v(nin)
wrdata t.free.stab.txt hst
quit
.endc
.end
