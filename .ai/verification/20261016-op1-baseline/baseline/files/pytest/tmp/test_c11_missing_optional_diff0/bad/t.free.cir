* spice_oracle: tcs_nmos_rload bias=free
.include "C:/pdk/sky130_fd_pr/cells/nfet_01v8/sky130_fd_pr__nfet_01v8__tt.pm3.spice"
.include "C:/pdk/sky130_fd_pr/cells/nfet_01v8/sky130_fd_pr__nfet_01v8__mismatch.corner.spice"
.include "C:/pdk/sky130_fd_pr/models/parameters/lod.spice"
.include "C:/pdk/sky130_fd_pr/cells/pfet_01v8/sky130_fd_pr__pfet_01v8__tt.pm3.spice"
.include "C:/pdk/sky130_fd_pr/cells/pfet_01v8/sky130_fd_pr__pfet_01v8__mismatch.corner.spice"
.temp 27
.option gmin=1e-15 reltol=1e-4 abstol=1e-14 vntol=1e-7
Vrail_vdd vdd 0 DC 1.8
Vrail_vsp vsp 0 DC 1.5
XM1 nout nin 0 0 sky130_fd_pr__nfet_01v8 l=5e-07 w=2e-06 m=2 ad=1e-12 as=1e-12 pd=4e-06 ps=4e-06
XMP1 pout pb vsp vdd sky130_fd_pr__pfet_01v8 l=5e-07 w=2e-06 m=3 ad=1e-12 as=1e-12 pd=4e-06 ps=4e-06
XM2 nout2 nin2 0 0 sky130_fd_pr__nfet_01v8 l=5e-07 w=2e-06 m=2 ad=1e-12 as=1e-12 pd=4e-06 ps=4e-06
Rp_RL vdd nout 100000
Cp_CL nout 0 1e-12
Rp_RP pout 0 10000
Rp_RL2 vdd nout2 100000
Vbias_pb pb 0 DC 0.3
.control
set noaskquit
op
echo OPSTART
print @m.xm1.msky130_fd_pr__nfet_01v8[id]
print @m.xm1.msky130_fd_pr__nfet_01v8[gm]
print @m.xm1.msky130_fd_pr__nfet_01v8[gds]
print @m.xm1.msky130_fd_pr__nfet_01v8[vth]
print @m.xm1.msky130_fd_pr__nfet_01v8[vdsat]
print @m.xm1.msky130_fd_pr__nfet_01v8[vgs]
print @m.xm1.msky130_fd_pr__nfet_01v8[vds]
print @m.xm1.msky130_fd_pr__nfet_01v8[vbs]
print @m.xmp1.msky130_fd_pr__pfet_01v8[id]
print @m.xmp1.msky130_fd_pr__pfet_01v8[gm]
print @m.xmp1.msky130_fd_pr__pfet_01v8[gds]
print @m.xmp1.msky130_fd_pr__pfet_01v8[vth]
print @m.xmp1.msky130_fd_pr__pfet_01v8[vdsat]
print @m.xmp1.msky130_fd_pr__pfet_01v8[vgs]
print @m.xmp1.msky130_fd_pr__pfet_01v8[vds]
print @m.xmp1.msky130_fd_pr__pfet_01v8[vbs]
print @m.xm2.msky130_fd_pr__nfet_01v8[id]
print @m.xm2.msky130_fd_pr__nfet_01v8[gm]
print @m.xm2.msky130_fd_pr__nfet_01v8[gds]
print @m.xm2.msky130_fd_pr__nfet_01v8[vth]
print @m.xm2.msky130_fd_pr__nfet_01v8[vdsat]
print @m.xm2.msky130_fd_pr__nfet_01v8[vgs]
print @m.xm2.msky130_fd_pr__nfet_01v8[vds]
print @m.xm2.msky130_fd_pr__nfet_01v8[vbs]
print v(nout)
print v(nin)
print v(pout)
print v(pb)
print v(vsp)
print v(vdd)
print v(nout2)
print v(nin2)
print i(vrail_vdd)
print i(vrail_vsp)
echo OPEND
ac dec 40 0.01 1e+10
let hout = v(nout) - v(nout2)
set wr_singlescale
wrdata t.free.ac.txt hout
quit
.endc
.end
