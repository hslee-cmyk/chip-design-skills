* spice_oracle: t5ota bias=free
.include "C:/pdk/sky130_fd_pr/cells/nfet_01v8/sky130_fd_pr__nfet_01v8__tt.pm3.spice"
.include "C:/pdk/sky130_fd_pr/cells/nfet_01v8/sky130_fd_pr__nfet_01v8__mismatch.corner.spice"
.include "C:/pdk/sky130_fd_pr/models/parameters/lod.spice"
.include "C:/pdk/sky130_fd_pr/cells/pfet_01v8/sky130_fd_pr__pfet_01v8__tt.pm3.spice"
.include "C:/pdk/sky130_fd_pr/cells/pfet_01v8/sky130_fd_pr__pfet_01v8__mismatch.corner.spice"
.temp 27
.option gmin=1e-15 reltol=1e-4 abstol=1e-14 vntol=1e-7
Vrail_vdd vdd 0 DC 1.8
XM1 d1 inp tail 0 sky130_fd_pr__nfet_01v8 l=1e-06 w=2e-06 m=2 ad=0 as=0 pd=0 ps=0
XM2 out inn tail 0 sky130_fd_pr__nfet_01v8 l=1e-06 w=2e-06 m=2 ad=0 as=0 pd=0 ps=0
XM3 d1 d1 vdd vdd sky130_fd_pr__pfet_01v8 l=1e-06 w=2e-06 m=2 ad=0 as=0 pd=0 ps=0
XM4 out d1 vdd vdd sky130_fd_pr__pfet_01v8 l=1e-06 w=2e-06 m=2 ad=0 as=0 pd=0 ps=0
Isrc_IT tail 0 DC 2e-05
Cp_CL out 0 1e-12
Vdc_inp dcs_inp 0 DC 0.9
Ldc_inp dcs_inp inp 1e+12
Cac_inp inp acs_inp 1
Vac_inp acs_inp 0 DC 0 AC 0.5
Efb_inn fbs_inn 0 out 0 1
Vofs_inn fbs_inn fbd_inn DC 0.004031
Lfb_inn fbd_inn inn 1e+12
Cac_inn inn acs_inn 1
Vac_inn acs_inn 0 DC 0 AC -0.5
.control
set noaskquit
alter vofs_inn dc = 0.90201505
alter vdc_inp dc = 0.00201595
echo SWP 0
op
echo OPSTART
print @m.xm1.msky130_fd_pr__nfet_01v8[id]
print @m.xm1.msky130_fd_pr__nfet_01v8[gm]
print @m.xm1.msky130_fd_pr__nfet_01v8[gds]
print @m.xm1.msky130_fd_pr__nfet_01v8[vth]
print @m.xm1.msky130_fd_pr__nfet_01v8[vdsat]
print @m.xm1.msky130_fd_pr__nfet_01v8[vgs]
print @m.xm1.msky130_fd_pr__nfet_01v8[vds]
print @m.xm1.msky130_fd_pr__nfet_01v8[vbs]
print @m.xm2.msky130_fd_pr__nfet_01v8[id]
print @m.xm2.msky130_fd_pr__nfet_01v8[gm]
print @m.xm2.msky130_fd_pr__nfet_01v8[gds]
print @m.xm2.msky130_fd_pr__nfet_01v8[vth]
print @m.xm2.msky130_fd_pr__nfet_01v8[vdsat]
print @m.xm2.msky130_fd_pr__nfet_01v8[vgs]
print @m.xm2.msky130_fd_pr__nfet_01v8[vds]
print @m.xm2.msky130_fd_pr__nfet_01v8[vbs]
print @m.xm3.msky130_fd_pr__pfet_01v8[id]
print @m.xm3.msky130_fd_pr__pfet_01v8[gm]
print @m.xm3.msky130_fd_pr__pfet_01v8[gds]
print @m.xm3.msky130_fd_pr__pfet_01v8[vth]
print @m.xm3.msky130_fd_pr__pfet_01v8[vdsat]
print @m.xm3.msky130_fd_pr__pfet_01v8[vgs]
print @m.xm3.msky130_fd_pr__pfet_01v8[vds]
print @m.xm3.msky130_fd_pr__pfet_01v8[vbs]
print @m.xm4.msky130_fd_pr__pfet_01v8[id]
print @m.xm4.msky130_fd_pr__pfet_01v8[gm]
print @m.xm4.msky130_fd_pr__pfet_01v8[gds]
print @m.xm4.msky130_fd_pr__pfet_01v8[vth]
print @m.xm4.msky130_fd_pr__pfet_01v8[vdsat]
print @m.xm4.msky130_fd_pr__pfet_01v8[vgs]
print @m.xm4.msky130_fd_pr__pfet_01v8[vds]
print @m.xm4.msky130_fd_pr__pfet_01v8[vbs]
print v(d1)
print v(inp)
print v(tail)
print v(out)
print v(inn)
print v(vdd)
print i(vrail_vdd)
echo OPEND
alter vofs_inn dc = 0.876300764286
alter vdc_inp dc = 0.0277302357143
echo SWP 1
op
echo OPSTART
print @m.xm1.msky130_fd_pr__nfet_01v8[id]
print @m.xm1.msky130_fd_pr__nfet_01v8[gm]
print @m.xm1.msky130_fd_pr__nfet_01v8[gds]
print @m.xm1.msky130_fd_pr__nfet_01v8[vth]
print @m.xm1.msky130_fd_pr__nfet_01v8[vdsat]
print @m.xm1.msky130_fd_pr__nfet_01v8[vgs]
print @m.xm1.msky130_fd_pr__nfet_01v8[vds]
print @m.xm1.msky130_fd_pr__nfet_01v8[vbs]
print @m.xm2.msky130_fd_pr__nfet_01v8[id]
print @m.xm2.msky130_fd_pr__nfet_01v8[gm]
print @m.xm2.msky130_fd_pr__nfet_01v8[gds]
print @m.xm2.msky130_fd_pr__nfet_01v8[vth]
print @m.xm2.msky130_fd_pr__nfet_01v8[vdsat]
print @m.xm2.msky130_fd_pr__nfet_01v8[vgs]
print @m.xm2.msky130_fd_pr__nfet_01v8[vds]
print @m.xm2.msky130_fd_pr__nfet_01v8[vbs]
print @m.xm3.msky130_fd_pr__pfet_01v8[id]
print @m.xm3.msky130_fd_pr__pfet_01v8[gm]
print @m.xm3.msky130_fd_pr__pfet_01v8[gds]
print @m.xm3.msky130_fd_pr__pfet_01v8[vth]
print @m.xm3.msky130_fd_pr__pfet_01v8[vdsat]
print @m.xm3.msky130_fd_pr__pfet_01v8[vgs]
print @m.xm3.msky130_fd_pr__pfet_01v8[vds]
print @m.xm3.msky130_fd_pr__pfet_01v8[vbs]
print @m.xm4.msky130_fd_pr__pfet_01v8[id]
print @m.xm4.msky130_fd_pr__pfet_01v8[gm]
print @m.xm4.msky130_fd_pr__pfet_01v8[gds]
print @m.xm4.msky130_fd_pr__pfet_01v8[vth]
print @m.xm4.msky130_fd_pr__pfet_01v8[vdsat]
print @m.xm4.msky130_fd_pr__pfet_01v8[vgs]
print @m.xm4.msky130_fd_pr__pfet_01v8[vds]
print @m.xm4.msky130_fd_pr__pfet_01v8[vbs]
print v(d1)
print v(inp)
print v(tail)
print v(out)
print v(inn)
print v(vdd)
print i(vrail_vdd)
echo OPEND
alter vofs_inn dc = 0.850586478571
alter vdc_inp dc = 0.0534445214286
echo SWP 2
op
echo OPSTART
print @m.xm1.msky130_fd_pr__nfet_01v8[id]
print @m.xm1.msky130_fd_pr__nfet_01v8[gm]
print @m.xm1.msky130_fd_pr__nfet_01v8[gds]
print @m.xm1.msky130_fd_pr__nfet_01v8[vth]
print @m.xm1.msky130_fd_pr__nfet_01v8[vdsat]
print @m.xm1.msky130_fd_pr__nfet_01v8[vgs]
print @m.xm1.msky130_fd_pr__nfet_01v8[vds]
print @m.xm1.msky130_fd_pr__nfet_01v8[vbs]
print @m.xm2.msky130_fd_pr__nfet_01v8[id]
print @m.xm2.msky130_fd_pr__nfet_01v8[gm]
print @m.xm2.msky130_fd_pr__nfet_01v8[gds]
print @m.xm2.msky130_fd_pr__nfet_01v8[vth]
print @m.xm2.msky130_fd_pr__nfet_01v8[vdsat]
print @m.xm2.msky130_fd_pr__nfet_01v8[vgs]
print @m.xm2.msky130_fd_pr__nfet_01v8[vds]
print @m.xm2.msky130_fd_pr__nfet_01v8[vbs]
print @m.xm3.msky130_fd_pr__pfet_01v8[id]
print @m.xm3.msky130_fd_pr__pfet_01v8[gm]
print @m.xm3.msky130_fd_pr__pfet_01v8[gds]
print @m.xm3.msky130_fd_pr__pfet_01v8[vth]
print @m.xm3.msky130_fd_pr__pfet_01v8[vdsat]
print @m.xm3.msky130_fd_pr__pfet_01v8[vgs]
print @m.xm3.msky130_fd_pr__pfet_01v8[vds]
print @m.xm3.msky130_fd_pr__pfet_01v8[vbs]
print @m.xm4.msky130_fd_pr__pfet_01v8[id]
print @m.xm4.msky130_fd_pr__pfet_01v8[gm]
print @m.xm4.msky130_fd_pr__pfet_01v8[gds]
print @m.xm4.msky130_fd_pr__pfet_01v8[vth]
print @m.xm4.msky130_fd_pr__pfet_01v8[vdsat]
print @m.xm4.msky130_fd_pr__pfet_01v8[vgs]
print @m.xm4.msky130_fd_pr__pfet_01v8[vds]
print @m.xm4.msky130_fd_pr__pfet_01v8[vbs]
print v(d1)
print v(inp)
print v(tail)
print v(out)
print v(inn)
print v(vdd)
print i(vrail_vdd)
echo OPEND
alter vofs_inn dc = 0.824872192857
alter vdc_inp dc = 0.0791588071429
echo SWP 3
op
echo OPSTART
print @m.xm1.msky130_fd_pr__nfet_01v8[id]
print @m.xm1.msky130_fd_pr__nfet_01v8[gm]
print @m.xm1.msky130_fd_pr__nfet_01v8[gds]
print @m.xm1.msky130_fd_pr__nfet_01v8[vth]
print @m.xm1.msky130_fd_pr__nfet_01v8[vdsat]
print @m.xm1.msky130_fd_pr__nfet_01v8[vgs]
print @m.xm1.msky130_fd_pr__nfet_01v8[vds]
print @m.xm1.msky130_fd_pr__nfet_01v8[vbs]
print @m.xm2.msky130_fd_pr__nfet_01v8[id]
print @m.xm2.msky130_fd_pr__nfet_01v8[gm]
print @m.xm2.msky130_fd_pr__nfet_01v8[gds]
print @m.xm2.msky130_fd_pr__nfet_01v8[vth]
print @m.xm2.msky130_fd_pr__nfet_01v8[vdsat]
print @m.xm2.msky130_fd_pr__nfet_01v8[vgs]
print @m.xm2.msky130_fd_pr__nfet_01v8[vds]
print @m.xm2.msky130_fd_pr__nfet_01v8[vbs]
print @m.xm3.msky130_fd_pr__pfet_01v8[id]
print @m.xm3.msky130_fd_pr__pfet_01v8[gm]
print @m.xm3.msky130_fd_pr__pfet_01v8[gds]
print @m.xm3.msky130_fd_pr__pfet_01v8[vth]
print @m.xm3.msky130_fd_pr__pfet_01v8[vdsat]
print @m.xm3.msky130_fd_pr__pfet_01v8[vgs]
print @m.xm3.msky130_fd_pr__pfet_01v8[vds]
print @m.xm3.msky130_fd_pr__pfet_01v8[vbs]
print @m.xm4.msky130_fd_pr__pfet_01v8[id]
print @m.xm4.msky130_fd_pr__pfet_01v8[gm]
print @m.xm4.msky130_fd_pr__pfet_01v8[gds]
print @m.xm4.msky130_fd_pr__pfet_01v8[vth]
print @m.xm4.msky130_fd_pr__pfet_01v8[vdsat]
print @m.xm4.msky130_fd_pr__pfet_01v8[vgs]
print @m.xm4.msky130_fd_pr__pfet_01v8[vds]
print @m.xm4.msky130_fd_pr__pfet_01v8[vbs]
print v(d1)
print v(inp)
print v(tail)
print v(out)
print v(inn)
print v(vdd)
print i(vrail_vdd)
echo OPEND
alter vofs_inn dc = 0.799157907143
alter vdc_inp dc = 0.104873092857
echo SWP 4
op
echo OPSTART
print @m.xm1.msky130_fd_pr__nfet_01v8[id]
print @m.xm1.msky130_fd_pr__nfet_01v8[gm]
print @m.xm1.msky130_fd_pr__nfet_01v8[gds]
print @m.xm1.msky130_fd_pr__nfet_01v8[vth]
print @m.xm1.msky130_fd_pr__nfet_01v8[vdsat]
print @m.xm1.msky130_fd_pr__nfet_01v8[vgs]
print @m.xm1.msky130_fd_pr__nfet_01v8[vds]
print @m.xm1.msky130_fd_pr__nfet_01v8[vbs]
print @m.xm2.msky130_fd_pr__nfet_01v8[id]
print @m.xm2.msky130_fd_pr__nfet_01v8[gm]
print @m.xm2.msky130_fd_pr__nfet_01v8[gds]
print @m.xm2.msky130_fd_pr__nfet_01v8[vth]
print @m.xm2.msky130_fd_pr__nfet_01v8[vdsat]
print @m.xm2.msky130_fd_pr__nfet_01v8[vgs]
print @m.xm2.msky130_fd_pr__nfet_01v8[vds]
print @m.xm2.msky130_fd_pr__nfet_01v8[vbs]
print @m.xm3.msky130_fd_pr__pfet_01v8[id]
print @m.xm3.msky130_fd_pr__pfet_01v8[gm]
print @m.xm3.msky130_fd_pr__pfet_01v8[gds]
print @m.xm3.msky130_fd_pr__pfet_01v8[vth]
print @m.xm3.msky130_fd_pr__pfet_01v8[vdsat]
print @m.xm3.msky130_fd_pr__pfet_01v8[vgs]
print @m.xm3.msky130_fd_pr__pfet_01v8[vds]
print @m.xm3.msky130_fd_pr__pfet_01v8[vbs]
print @m.xm4.msky130_fd_pr__pfet_01v8[id]
print @m.xm4.msky130_fd_pr__pfet_01v8[gm]
print @m.xm4.msky130_fd_pr__pfet_01v8[gds]
print @m.xm4.msky130_fd_pr__pfet_01v8[vth]
print @m.xm4.msky130_fd_pr__pfet_01v8[vdsat]
print @m.xm4.msky130_fd_pr__pfet_01v8[vgs]
print @m.xm4.msky130_fd_pr__pfet_01v8[vds]
print @m.xm4.msky130_fd_pr__pfet_01v8[vbs]
print v(d1)
print v(inp)
print v(tail)
print v(out)
print v(inn)
print v(vdd)
print i(vrail_vdd)
echo OPEND
alter vofs_inn dc = 0.773443621429
alter vdc_inp dc = 0.130587378571
echo SWP 5
op
echo OPSTART
print @m.xm1.msky130_fd_pr__nfet_01v8[id]
print @m.xm1.msky130_fd_pr__nfet_01v8[gm]
print @m.xm1.msky130_fd_pr__nfet_01v8[gds]
print @m.xm1.msky130_fd_pr__nfet_01v8[vth]
print @m.xm1.msky130_fd_pr__nfet_01v8[vdsat]
print @m.xm1.msky130_fd_pr__nfet_01v8[vgs]
print @m.xm1.msky130_fd_pr__nfet_01v8[vds]
print @m.xm1.msky130_fd_pr__nfet_01v8[vbs]
print @m.xm2.msky130_fd_pr__nfet_01v8[id]
print @m.xm2.msky130_fd_pr__nfet_01v8[gm]
print @m.xm2.msky130_fd_pr__nfet_01v8[gds]
print @m.xm2.msky130_fd_pr__nfet_01v8[vth]
print @m.xm2.msky130_fd_pr__nfet_01v8[vdsat]
print @m.xm2.msky130_fd_pr__nfet_01v8[vgs]
print @m.xm2.msky130_fd_pr__nfet_01v8[vds]
print @m.xm2.msky130_fd_pr__nfet_01v8[vbs]
print @m.xm3.msky130_fd_pr__pfet_01v8[id]
print @m.xm3.msky130_fd_pr__pfet_01v8[gm]
print @m.xm3.msky130_fd_pr__pfet_01v8[gds]
print @m.xm3.msky130_fd_pr__pfet_01v8[vth]
print @m.xm3.msky130_fd_pr__pfet_01v8[vdsat]
print @m.xm3.msky130_fd_pr__pfet_01v8[vgs]
print @m.xm3.msky130_fd_pr__pfet_01v8[vds]
print @m.xm3.msky130_fd_pr__pfet_01v8[vbs]
print @m.xm4.msky130_fd_pr__pfet_01v8[id]
print @m.xm4.msky130_fd_pr__pfet_01v8[gm]
print @m.xm4.msky130_fd_pr__pfet_01v8[gds]
print @m.xm4.msky130_fd_pr__pfet_01v8[vth]
print @m.xm4.msky130_fd_pr__pfet_01v8[vdsat]
print @m.xm4.msky130_fd_pr__pfet_01v8[vgs]
print @m.xm4.msky130_fd_pr__pfet_01v8[vds]
print @m.xm4.msky130_fd_pr__pfet_01v8[vbs]
print v(d1)
print v(inp)
print v(tail)
print v(out)
print v(inn)
print v(vdd)
print i(vrail_vdd)
echo OPEND
alter vofs_inn dc = 0.747729335714
alter vdc_inp dc = 0.156301664286
echo SWP 6
op
echo OPSTART
print @m.xm1.msky130_fd_pr__nfet_01v8[id]
print @m.xm1.msky130_fd_pr__nfet_01v8[gm]
print @m.xm1.msky130_fd_pr__nfet_01v8[gds]
print @m.xm1.msky130_fd_pr__nfet_01v8[vth]
print @m.xm1.msky130_fd_pr__nfet_01v8[vdsat]
print @m.xm1.msky130_fd_pr__nfet_01v8[vgs]
print @m.xm1.msky130_fd_pr__nfet_01v8[vds]
print @m.xm1.msky130_fd_pr__nfet_01v8[vbs]
print @m.xm2.msky130_fd_pr__nfet_01v8[id]
print @m.xm2.msky130_fd_pr__nfet_01v8[gm]
print @m.xm2.msky130_fd_pr__nfet_01v8[gds]
print @m.xm2.msky130_fd_pr__nfet_01v8[vth]
print @m.xm2.msky130_fd_pr__nfet_01v8[vdsat]
print @m.xm2.msky130_fd_pr__nfet_01v8[vgs]
print @m.xm2.msky130_fd_pr__nfet_01v8[vds]
print @m.xm2.msky130_fd_pr__nfet_01v8[vbs]
print @m.xm3.msky130_fd_pr__pfet_01v8[id]
print @m.xm3.msky130_fd_pr__pfet_01v8[gm]
print @m.xm3.msky130_fd_pr__pfet_01v8[gds]
print @m.xm3.msky130_fd_pr__pfet_01v8[vth]
print @m.xm3.msky130_fd_pr__pfet_01v8[vdsat]
print @m.xm3.msky130_fd_pr__pfet_01v8[vgs]
print @m.xm3.msky130_fd_pr__pfet_01v8[vds]
print @m.xm3.msky130_fd_pr__pfet_01v8[vbs]
print @m.xm4.msky130_fd_pr__pfet_01v8[id]
print @m.xm4.msky130_fd_pr__pfet_01v8[gm]
print @m.xm4.msky130_fd_pr__pfet_01v8[gds]
print @m.xm4.msky130_fd_pr__pfet_01v8[vth]
print @m.xm4.msky130_fd_pr__pfet_01v8[vdsat]
print @m.xm4.msky130_fd_pr__pfet_01v8[vgs]
print @m.xm4.msky130_fd_pr__pfet_01v8[vds]
print @m.xm4.msky130_fd_pr__pfet_01v8[vbs]
print v(d1)
print v(inp)
print v(tail)
print v(out)
print v(inn)
print v(vdd)
print i(vrail_vdd)
echo OPEND
alter vofs_inn dc = 0.72201505
alter vdc_inp dc = 0.18201595
echo SWP 7
op
echo OPSTART
print @m.xm1.msky130_fd_pr__nfet_01v8[id]
print @m.xm1.msky130_fd_pr__nfet_01v8[gm]
print @m.xm1.msky130_fd_pr__nfet_01v8[gds]
print @m.xm1.msky130_fd_pr__nfet_01v8[vth]
print @m.xm1.msky130_fd_pr__nfet_01v8[vdsat]
print @m.xm1.msky130_fd_pr__nfet_01v8[vgs]
print @m.xm1.msky130_fd_pr__nfet_01v8[vds]
print @m.xm1.msky130_fd_pr__nfet_01v8[vbs]
print @m.xm2.msky130_fd_pr__nfet_01v8[id]
print @m.xm2.msky130_fd_pr__nfet_01v8[gm]
print @m.xm2.msky130_fd_pr__nfet_01v8[gds]
print @m.xm2.msky130_fd_pr__nfet_01v8[vth]
print @m.xm2.msky130_fd_pr__nfet_01v8[vdsat]
print @m.xm2.msky130_fd_pr__nfet_01v8[vgs]
print @m.xm2.msky130_fd_pr__nfet_01v8[vds]
print @m.xm2.msky130_fd_pr__nfet_01v8[vbs]
print @m.xm3.msky130_fd_pr__pfet_01v8[id]
print @m.xm3.msky130_fd_pr__pfet_01v8[gm]
print @m.xm3.msky130_fd_pr__pfet_01v8[gds]
print @m.xm3.msky130_fd_pr__pfet_01v8[vth]
print @m.xm3.msky130_fd_pr__pfet_01v8[vdsat]
print @m.xm3.msky130_fd_pr__pfet_01v8[vgs]
print @m.xm3.msky130_fd_pr__pfet_01v8[vds]
print @m.xm3.msky130_fd_pr__pfet_01v8[vbs]
print @m.xm4.msky130_fd_pr__pfet_01v8[id]
print @m.xm4.msky130_fd_pr__pfet_01v8[gm]
print @m.xm4.msky130_fd_pr__pfet_01v8[gds]
print @m.xm4.msky130_fd_pr__pfet_01v8[vth]
print @m.xm4.msky130_fd_pr__pfet_01v8[vdsat]
print @m.xm4.msky130_fd_pr__pfet_01v8[vgs]
print @m.xm4.msky130_fd_pr__pfet_01v8[vds]
print @m.xm4.msky130_fd_pr__pfet_01v8[vbs]
print v(d1)
print v(inp)
print v(tail)
print v(out)
print v(inn)
print v(vdd)
print i(vrail_vdd)
echo OPEND
alter vofs_inn dc = 0.696300764286
alter vdc_inp dc = 0.207730235714
echo SWP 8
op
echo OPSTART
print @m.xm1.msky130_fd_pr__nfet_01v8[id]
print @m.xm1.msky130_fd_pr__nfet_01v8[gm]
print @m.xm1.msky130_fd_pr__nfet_01v8[gds]
print @m.xm1.msky130_fd_pr__nfet_01v8[vth]
print @m.xm1.msky130_fd_pr__nfet_01v8[vdsat]
print @m.xm1.msky130_fd_pr__nfet_01v8[vgs]
print @m.xm1.msky130_fd_pr__nfet_01v8[vds]
print @m.xm1.msky130_fd_pr__nfet_01v8[vbs]
print @m.xm2.msky130_fd_pr__nfet_01v8[id]
print @m.xm2.msky130_fd_pr__nfet_01v8[gm]
print @m.xm2.msky130_fd_pr__nfet_01v8[gds]
print @m.xm2.msky130_fd_pr__nfet_01v8[vth]
print @m.xm2.msky130_fd_pr__nfet_01v8[vdsat]
print @m.xm2.msky130_fd_pr__nfet_01v8[vgs]
print @m.xm2.msky130_fd_pr__nfet_01v8[vds]
print @m.xm2.msky130_fd_pr__nfet_01v8[vbs]
print @m.xm3.msky130_fd_pr__pfet_01v8[id]
print @m.xm3.msky130_fd_pr__pfet_01v8[gm]
print @m.xm3.msky130_fd_pr__pfet_01v8[gds]
print @m.xm3.msky130_fd_pr__pfet_01v8[vth]
print @m.xm3.msky130_fd_pr__pfet_01v8[vdsat]
print @m.xm3.msky130_fd_pr__pfet_01v8[vgs]
print @m.xm3.msky130_fd_pr__pfet_01v8[vds]
print @m.xm3.msky130_fd_pr__pfet_01v8[vbs]
print @m.xm4.msky130_fd_pr__pfet_01v8[id]
print @m.xm4.msky130_fd_pr__pfet_01v8[gm]
print @m.xm4.msky130_fd_pr__pfet_01v8[gds]
print @m.xm4.msky130_fd_pr__pfet_01v8[vth]
print @m.xm4.msky130_fd_pr__pfet_01v8[vdsat]
print @m.xm4.msky130_fd_pr__pfet_01v8[vgs]
print @m.xm4.msky130_fd_pr__pfet_01v8[vds]
print @m.xm4.msky130_fd_pr__pfet_01v8[vbs]
print v(d1)
print v(inp)
print v(tail)
print v(out)
print v(inn)
print v(vdd)
print i(vrail_vdd)
echo OPEND
alter vofs_inn dc = 0.670586478571
alter vdc_inp dc = 0.233444521429
echo SWP 9
op
echo OPSTART
print @m.xm1.msky130_fd_pr__nfet_01v8[id]
print @m.xm1.msky130_fd_pr__nfet_01v8[gm]
print @m.xm1.msky130_fd_pr__nfet_01v8[gds]
print @m.xm1.msky130_fd_pr__nfet_01v8[vth]
print @m.xm1.msky130_fd_pr__nfet_01v8[vdsat]
print @m.xm1.msky130_fd_pr__nfet_01v8[vgs]
print @m.xm1.msky130_fd_pr__nfet_01v8[vds]
print @m.xm1.msky130_fd_pr__nfet_01v8[vbs]
print @m.xm2.msky130_fd_pr__nfet_01v8[id]
print @m.xm2.msky130_fd_pr__nfet_01v8[gm]
print @m.xm2.msky130_fd_pr__nfet_01v8[gds]
print @m.xm2.msky130_fd_pr__nfet_01v8[vth]
print @m.xm2.msky130_fd_pr__nfet_01v8[vdsat]
print @m.xm2.msky130_fd_pr__nfet_01v8[vgs]
print @m.xm2.msky130_fd_pr__nfet_01v8[vds]
print @m.xm2.msky130_fd_pr__nfet_01v8[vbs]
print @m.xm3.msky130_fd_pr__pfet_01v8[id]
print @m.xm3.msky130_fd_pr__pfet_01v8[gm]
print @m.xm3.msky130_fd_pr__pfet_01v8[gds]
print @m.xm3.msky130_fd_pr__pfet_01v8[vth]
print @m.xm3.msky130_fd_pr__pfet_01v8[vdsat]
print @m.xm3.msky130_fd_pr__pfet_01v8[vgs]
print @m.xm3.msky130_fd_pr__pfet_01v8[vds]
print @m.xm3.msky130_fd_pr__pfet_01v8[vbs]
print @m.xm4.msky130_fd_pr__pfet_01v8[id]
print @m.xm4.msky130_fd_pr__pfet_01v8[gm]
print @m.xm4.msky130_fd_pr__pfet_01v8[gds]
print @m.xm4.msky130_fd_pr__pfet_01v8[vth]
print @m.xm4.msky130_fd_pr__pfet_01v8[vdsat]
print @m.xm4.msky130_fd_pr__pfet_01v8[vgs]
print @m.xm4.msky130_fd_pr__pfet_01v8[vds]
print @m.xm4.msky130_fd_pr__pfet_01v8[vbs]
print v(d1)
print v(inp)
print v(tail)
print v(out)
print v(inn)
print v(vdd)
print i(vrail_vdd)
echo OPEND
alter vofs_inn dc = 0.644872192857
alter vdc_inp dc = 0.259158807143
echo SWP 10
op
echo OPSTART
print @m.xm1.msky130_fd_pr__nfet_01v8[id]
print @m.xm1.msky130_fd_pr__nfet_01v8[gm]
print @m.xm1.msky130_fd_pr__nfet_01v8[gds]
print @m.xm1.msky130_fd_pr__nfet_01v8[vth]
print @m.xm1.msky130_fd_pr__nfet_01v8[vdsat]
print @m.xm1.msky130_fd_pr__nfet_01v8[vgs]
print @m.xm1.msky130_fd_pr__nfet_01v8[vds]
print @m.xm1.msky130_fd_pr__nfet_01v8[vbs]
print @m.xm2.msky130_fd_pr__nfet_01v8[id]
print @m.xm2.msky130_fd_pr__nfet_01v8[gm]
print @m.xm2.msky130_fd_pr__nfet_01v8[gds]
print @m.xm2.msky130_fd_pr__nfet_01v8[vth]
print @m.xm2.msky130_fd_pr__nfet_01v8[vdsat]
print @m.xm2.msky130_fd_pr__nfet_01v8[vgs]
print @m.xm2.msky130_fd_pr__nfet_01v8[vds]
print @m.xm2.msky130_fd_pr__nfet_01v8[vbs]
print @m.xm3.msky130_fd_pr__pfet_01v8[id]
print @m.xm3.msky130_fd_pr__pfet_01v8[gm]
print @m.xm3.msky130_fd_pr__pfet_01v8[gds]
print @m.xm3.msky130_fd_pr__pfet_01v8[vth]
print @m.xm3.msky130_fd_pr__pfet_01v8[vdsat]
print @m.xm3.msky130_fd_pr__pfet_01v8[vgs]
print @m.xm3.msky130_fd_pr__pfet_01v8[vds]
print @m.xm3.msky130_fd_pr__pfet_01v8[vbs]
print @m.xm4.msky130_fd_pr__pfet_01v8[id]
print @m.xm4.msky130_fd_pr__pfet_01v8[gm]
print @m.xm4.msky130_fd_pr__pfet_01v8[gds]
print @m.xm4.msky130_fd_pr__pfet_01v8[vth]
print @m.xm4.msky130_fd_pr__pfet_01v8[vdsat]
print @m.xm4.msky130_fd_pr__pfet_01v8[vgs]
print @m.xm4.msky130_fd_pr__pfet_01v8[vds]
print @m.xm4.msky130_fd_pr__pfet_01v8[vbs]
print v(d1)
print v(inp)
print v(tail)
print v(out)
print v(inn)
print v(vdd)
print i(vrail_vdd)
echo OPEND
alter vofs_inn dc = 0.619157907143
alter vdc_inp dc = 0.284873092857
echo SWP 11
op
echo OPSTART
print @m.xm1.msky130_fd_pr__nfet_01v8[id]
print @m.xm1.msky130_fd_pr__nfet_01v8[gm]
print @m.xm1.msky130_fd_pr__nfet_01v8[gds]
print @m.xm1.msky130_fd_pr__nfet_01v8[vth]
print @m.xm1.msky130_fd_pr__nfet_01v8[vdsat]
print @m.xm1.msky130_fd_pr__nfet_01v8[vgs]
print @m.xm1.msky130_fd_pr__nfet_01v8[vds]
print @m.xm1.msky130_fd_pr__nfet_01v8[vbs]
print @m.xm2.msky130_fd_pr__nfet_01v8[id]
print @m.xm2.msky130_fd_pr__nfet_01v8[gm]
print @m.xm2.msky130_fd_pr__nfet_01v8[gds]
print @m.xm2.msky130_fd_pr__nfet_01v8[vth]
print @m.xm2.msky130_fd_pr__nfet_01v8[vdsat]
print @m.xm2.msky130_fd_pr__nfet_01v8[vgs]
print @m.xm2.msky130_fd_pr__nfet_01v8[vds]
print @m.xm2.msky130_fd_pr__nfet_01v8[vbs]
print @m.xm3.msky130_fd_pr__pfet_01v8[id]
print @m.xm3.msky130_fd_pr__pfet_01v8[gm]
print @m.xm3.msky130_fd_pr__pfet_01v8[gds]
print @m.xm3.msky130_fd_pr__pfet_01v8[vth]
print @m.xm3.msky130_fd_pr__pfet_01v8[vdsat]
print @m.xm3.msky130_fd_pr__pfet_01v8[vgs]
print @m.xm3.msky130_fd_pr__pfet_01v8[vds]
print @m.xm3.msky130_fd_pr__pfet_01v8[vbs]
print @m.xm4.msky130_fd_pr__pfet_01v8[id]
print @m.xm4.msky130_fd_pr__pfet_01v8[gm]
print @m.xm4.msky130_fd_pr__pfet_01v8[gds]
print @m.xm4.msky130_fd_pr__pfet_01v8[vth]
print @m.xm4.msky130_fd_pr__pfet_01v8[vdsat]
print @m.xm4.msky130_fd_pr__pfet_01v8[vgs]
print @m.xm4.msky130_fd_pr__pfet_01v8[vds]
print @m.xm4.msky130_fd_pr__pfet_01v8[vbs]
print v(d1)
print v(inp)
print v(tail)
print v(out)
print v(inn)
print v(vdd)
print i(vrail_vdd)
echo OPEND
alter vofs_inn dc = 0.593443621429
alter vdc_inp dc = 0.310587378571
echo SWP 12
op
echo OPSTART
print @m.xm1.msky130_fd_pr__nfet_01v8[id]
print @m.xm1.msky130_fd_pr__nfet_01v8[gm]
print @m.xm1.msky130_fd_pr__nfet_01v8[gds]
print @m.xm1.msky130_fd_pr__nfet_01v8[vth]
print @m.xm1.msky130_fd_pr__nfet_01v8[vdsat]
print @m.xm1.msky130_fd_pr__nfet_01v8[vgs]
print @m.xm1.msky130_fd_pr__nfet_01v8[vds]
print @m.xm1.msky130_fd_pr__nfet_01v8[vbs]
print @m.xm2.msky130_fd_pr__nfet_01v8[id]
print @m.xm2.msky130_fd_pr__nfet_01v8[gm]
print @m.xm2.msky130_fd_pr__nfet_01v8[gds]
print @m.xm2.msky130_fd_pr__nfet_01v8[vth]
print @m.xm2.msky130_fd_pr__nfet_01v8[vdsat]
print @m.xm2.msky130_fd_pr__nfet_01v8[vgs]
print @m.xm2.msky130_fd_pr__nfet_01v8[vds]
print @m.xm2.msky130_fd_pr__nfet_01v8[vbs]
print @m.xm3.msky130_fd_pr__pfet_01v8[id]
print @m.xm3.msky130_fd_pr__pfet_01v8[gm]
print @m.xm3.msky130_fd_pr__pfet_01v8[gds]
print @m.xm3.msky130_fd_pr__pfet_01v8[vth]
print @m.xm3.msky130_fd_pr__pfet_01v8[vdsat]
print @m.xm3.msky130_fd_pr__pfet_01v8[vgs]
print @m.xm3.msky130_fd_pr__pfet_01v8[vds]
print @m.xm3.msky130_fd_pr__pfet_01v8[vbs]
print @m.xm4.msky130_fd_pr__pfet_01v8[id]
print @m.xm4.msky130_fd_pr__pfet_01v8[gm]
print @m.xm4.msky130_fd_pr__pfet_01v8[gds]
print @m.xm4.msky130_fd_pr__pfet_01v8[vth]
print @m.xm4.msky130_fd_pr__pfet_01v8[vdsat]
print @m.xm4.msky130_fd_pr__pfet_01v8[vgs]
print @m.xm4.msky130_fd_pr__pfet_01v8[vds]
print @m.xm4.msky130_fd_pr__pfet_01v8[vbs]
print v(d1)
print v(inp)
print v(tail)
print v(out)
print v(inn)
print v(vdd)
print i(vrail_vdd)
echo OPEND
alter vofs_inn dc = 0.567729335714
alter vdc_inp dc = 0.336301664286
echo SWP 13
op
echo OPSTART
print @m.xm1.msky130_fd_pr__nfet_01v8[id]
print @m.xm1.msky130_fd_pr__nfet_01v8[gm]
print @m.xm1.msky130_fd_pr__nfet_01v8[gds]
print @m.xm1.msky130_fd_pr__nfet_01v8[vth]
print @m.xm1.msky130_fd_pr__nfet_01v8[vdsat]
print @m.xm1.msky130_fd_pr__nfet_01v8[vgs]
print @m.xm1.msky130_fd_pr__nfet_01v8[vds]
print @m.xm1.msky130_fd_pr__nfet_01v8[vbs]
print @m.xm2.msky130_fd_pr__nfet_01v8[id]
print @m.xm2.msky130_fd_pr__nfet_01v8[gm]
print @m.xm2.msky130_fd_pr__nfet_01v8[gds]
print @m.xm2.msky130_fd_pr__nfet_01v8[vth]
print @m.xm2.msky130_fd_pr__nfet_01v8[vdsat]
print @m.xm2.msky130_fd_pr__nfet_01v8[vgs]
print @m.xm2.msky130_fd_pr__nfet_01v8[vds]
print @m.xm2.msky130_fd_pr__nfet_01v8[vbs]
print @m.xm3.msky130_fd_pr__pfet_01v8[id]
print @m.xm3.msky130_fd_pr__pfet_01v8[gm]
print @m.xm3.msky130_fd_pr__pfet_01v8[gds]
print @m.xm3.msky130_fd_pr__pfet_01v8[vth]
print @m.xm3.msky130_fd_pr__pfet_01v8[vdsat]
print @m.xm3.msky130_fd_pr__pfet_01v8[vgs]
print @m.xm3.msky130_fd_pr__pfet_01v8[vds]
print @m.xm3.msky130_fd_pr__pfet_01v8[vbs]
print @m.xm4.msky130_fd_pr__pfet_01v8[id]
print @m.xm4.msky130_fd_pr__pfet_01v8[gm]
print @m.xm4.msky130_fd_pr__pfet_01v8[gds]
print @m.xm4.msky130_fd_pr__pfet_01v8[vth]
print @m.xm4.msky130_fd_pr__pfet_01v8[vdsat]
print @m.xm4.msky130_fd_pr__pfet_01v8[vgs]
print @m.xm4.msky130_fd_pr__pfet_01v8[vds]
print @m.xm4.msky130_fd_pr__pfet_01v8[vbs]
print v(d1)
print v(inp)
print v(tail)
print v(out)
print v(inn)
print v(vdd)
print i(vrail_vdd)
echo OPEND
alter vofs_inn dc = 0.54201505
alter vdc_inp dc = 0.36201595
echo SWP 14
op
echo OPSTART
print @m.xm1.msky130_fd_pr__nfet_01v8[id]
print @m.xm1.msky130_fd_pr__nfet_01v8[gm]
print @m.xm1.msky130_fd_pr__nfet_01v8[gds]
print @m.xm1.msky130_fd_pr__nfet_01v8[vth]
print @m.xm1.msky130_fd_pr__nfet_01v8[vdsat]
print @m.xm1.msky130_fd_pr__nfet_01v8[vgs]
print @m.xm1.msky130_fd_pr__nfet_01v8[vds]
print @m.xm1.msky130_fd_pr__nfet_01v8[vbs]
print @m.xm2.msky130_fd_pr__nfet_01v8[id]
print @m.xm2.msky130_fd_pr__nfet_01v8[gm]
print @m.xm2.msky130_fd_pr__nfet_01v8[gds]
print @m.xm2.msky130_fd_pr__nfet_01v8[vth]
print @m.xm2.msky130_fd_pr__nfet_01v8[vdsat]
print @m.xm2.msky130_fd_pr__nfet_01v8[vgs]
print @m.xm2.msky130_fd_pr__nfet_01v8[vds]
print @m.xm2.msky130_fd_pr__nfet_01v8[vbs]
print @m.xm3.msky130_fd_pr__pfet_01v8[id]
print @m.xm3.msky130_fd_pr__pfet_01v8[gm]
print @m.xm3.msky130_fd_pr__pfet_01v8[gds]
print @m.xm3.msky130_fd_pr__pfet_01v8[vth]
print @m.xm3.msky130_fd_pr__pfet_01v8[vdsat]
print @m.xm3.msky130_fd_pr__pfet_01v8[vgs]
print @m.xm3.msky130_fd_pr__pfet_01v8[vds]
print @m.xm3.msky130_fd_pr__pfet_01v8[vbs]
print @m.xm4.msky130_fd_pr__pfet_01v8[id]
print @m.xm4.msky130_fd_pr__pfet_01v8[gm]
print @m.xm4.msky130_fd_pr__pfet_01v8[gds]
print @m.xm4.msky130_fd_pr__pfet_01v8[vth]
print @m.xm4.msky130_fd_pr__pfet_01v8[vdsat]
print @m.xm4.msky130_fd_pr__pfet_01v8[vgs]
print @m.xm4.msky130_fd_pr__pfet_01v8[vds]
print @m.xm4.msky130_fd_pr__pfet_01v8[vbs]
print v(d1)
print v(inp)
print v(tail)
print v(out)
print v(inn)
print v(vdd)
print i(vrail_vdd)
echo OPEND
alter vofs_inn dc = 0.516300764286
alter vdc_inp dc = 0.387730235714
echo SWP 15
op
echo OPSTART
print @m.xm1.msky130_fd_pr__nfet_01v8[id]
print @m.xm1.msky130_fd_pr__nfet_01v8[gm]
print @m.xm1.msky130_fd_pr__nfet_01v8[gds]
print @m.xm1.msky130_fd_pr__nfet_01v8[vth]
print @m.xm1.msky130_fd_pr__nfet_01v8[vdsat]
print @m.xm1.msky130_fd_pr__nfet_01v8[vgs]
print @m.xm1.msky130_fd_pr__nfet_01v8[vds]
print @m.xm1.msky130_fd_pr__nfet_01v8[vbs]
print @m.xm2.msky130_fd_pr__nfet_01v8[id]
print @m.xm2.msky130_fd_pr__nfet_01v8[gm]
print @m.xm2.msky130_fd_pr__nfet_01v8[gds]
print @m.xm2.msky130_fd_pr__nfet_01v8[vth]
print @m.xm2.msky130_fd_pr__nfet_01v8[vdsat]
print @m.xm2.msky130_fd_pr__nfet_01v8[vgs]
print @m.xm2.msky130_fd_pr__nfet_01v8[vds]
print @m.xm2.msky130_fd_pr__nfet_01v8[vbs]
print @m.xm3.msky130_fd_pr__pfet_01v8[id]
print @m.xm3.msky130_fd_pr__pfet_01v8[gm]
print @m.xm3.msky130_fd_pr__pfet_01v8[gds]
print @m.xm3.msky130_fd_pr__pfet_01v8[vth]
print @m.xm3.msky130_fd_pr__pfet_01v8[vdsat]
print @m.xm3.msky130_fd_pr__pfet_01v8[vgs]
print @m.xm3.msky130_fd_pr__pfet_01v8[vds]
print @m.xm3.msky130_fd_pr__pfet_01v8[vbs]
print @m.xm4.msky130_fd_pr__pfet_01v8[id]
print @m.xm4.msky130_fd_pr__pfet_01v8[gm]
print @m.xm4.msky130_fd_pr__pfet_01v8[gds]
print @m.xm4.msky130_fd_pr__pfet_01v8[vth]
print @m.xm4.msky130_fd_pr__pfet_01v8[vdsat]
print @m.xm4.msky130_fd_pr__pfet_01v8[vgs]
print @m.xm4.msky130_fd_pr__pfet_01v8[vds]
print @m.xm4.msky130_fd_pr__pfet_01v8[vbs]
print v(d1)
print v(inp)
print v(tail)
print v(out)
print v(inn)
print v(vdd)
print i(vrail_vdd)
echo OPEND
alter vofs_inn dc = 0.490586478571
alter vdc_inp dc = 0.413444521429
echo SWP 16
op
echo OPSTART
print @m.xm1.msky130_fd_pr__nfet_01v8[id]
print @m.xm1.msky130_fd_pr__nfet_01v8[gm]
print @m.xm1.msky130_fd_pr__nfet_01v8[gds]
print @m.xm1.msky130_fd_pr__nfet_01v8[vth]
print @m.xm1.msky130_fd_pr__nfet_01v8[vdsat]
print @m.xm1.msky130_fd_pr__nfet_01v8[vgs]
print @m.xm1.msky130_fd_pr__nfet_01v8[vds]
print @m.xm1.msky130_fd_pr__nfet_01v8[vbs]
print @m.xm2.msky130_fd_pr__nfet_01v8[id]
print @m.xm2.msky130_fd_pr__nfet_01v8[gm]
print @m.xm2.msky130_fd_pr__nfet_01v8[gds]
print @m.xm2.msky130_fd_pr__nfet_01v8[vth]
print @m.xm2.msky130_fd_pr__nfet_01v8[vdsat]
print @m.xm2.msky130_fd_pr__nfet_01v8[vgs]
print @m.xm2.msky130_fd_pr__nfet_01v8[vds]
print @m.xm2.msky130_fd_pr__nfet_01v8[vbs]
print @m.xm3.msky130_fd_pr__pfet_01v8[id]
print @m.xm3.msky130_fd_pr__pfet_01v8[gm]
print @m.xm3.msky130_fd_pr__pfet_01v8[gds]
print @m.xm3.msky130_fd_pr__pfet_01v8[vth]
print @m.xm3.msky130_fd_pr__pfet_01v8[vdsat]
print @m.xm3.msky130_fd_pr__pfet_01v8[vgs]
print @m.xm3.msky130_fd_pr__pfet_01v8[vds]
print @m.xm3.msky130_fd_pr__pfet_01v8[vbs]
print @m.xm4.msky130_fd_pr__pfet_01v8[id]
print @m.xm4.msky130_fd_pr__pfet_01v8[gm]
print @m.xm4.msky130_fd_pr__pfet_01v8[gds]
print @m.xm4.msky130_fd_pr__pfet_01v8[vth]
print @m.xm4.msky130_fd_pr__pfet_01v8[vdsat]
print @m.xm4.msky130_fd_pr__pfet_01v8[vgs]
print @m.xm4.msky130_fd_pr__pfet_01v8[vds]
print @m.xm4.msky130_fd_pr__pfet_01v8[vbs]
print v(d1)
print v(inp)
print v(tail)
print v(out)
print v(inn)
print v(vdd)
print i(vrail_vdd)
echo OPEND
alter vofs_inn dc = 0.464872192857
alter vdc_inp dc = 0.439158807143
echo SWP 17
op
echo OPSTART
print @m.xm1.msky130_fd_pr__nfet_01v8[id]
print @m.xm1.msky130_fd_pr__nfet_01v8[gm]
print @m.xm1.msky130_fd_pr__nfet_01v8[gds]
print @m.xm1.msky130_fd_pr__nfet_01v8[vth]
print @m.xm1.msky130_fd_pr__nfet_01v8[vdsat]
print @m.xm1.msky130_fd_pr__nfet_01v8[vgs]
print @m.xm1.msky130_fd_pr__nfet_01v8[vds]
print @m.xm1.msky130_fd_pr__nfet_01v8[vbs]
print @m.xm2.msky130_fd_pr__nfet_01v8[id]
print @m.xm2.msky130_fd_pr__nfet_01v8[gm]
print @m.xm2.msky130_fd_pr__nfet_01v8[gds]
print @m.xm2.msky130_fd_pr__nfet_01v8[vth]
print @m.xm2.msky130_fd_pr__nfet_01v8[vdsat]
print @m.xm2.msky130_fd_pr__nfet_01v8[vgs]
print @m.xm2.msky130_fd_pr__nfet_01v8[vds]
print @m.xm2.msky130_fd_pr__nfet_01v8[vbs]
print @m.xm3.msky130_fd_pr__pfet_01v8[id]
print @m.xm3.msky130_fd_pr__pfet_01v8[gm]
print @m.xm3.msky130_fd_pr__pfet_01v8[gds]
print @m.xm3.msky130_fd_pr__pfet_01v8[vth]
print @m.xm3.msky130_fd_pr__pfet_01v8[vdsat]
print @m.xm3.msky130_fd_pr__pfet_01v8[vgs]
print @m.xm3.msky130_fd_pr__pfet_01v8[vds]
print @m.xm3.msky130_fd_pr__pfet_01v8[vbs]
print @m.xm4.msky130_fd_pr__pfet_01v8[id]
print @m.xm4.msky130_fd_pr__pfet_01v8[gm]
print @m.xm4.msky130_fd_pr__pfet_01v8[gds]
print @m.xm4.msky130_fd_pr__pfet_01v8[vth]
print @m.xm4.msky130_fd_pr__pfet_01v8[vdsat]
print @m.xm4.msky130_fd_pr__pfet_01v8[vgs]
print @m.xm4.msky130_fd_pr__pfet_01v8[vds]
print @m.xm4.msky130_fd_pr__pfet_01v8[vbs]
print v(d1)
print v(inp)
print v(tail)
print v(out)
print v(inn)
print v(vdd)
print i(vrail_vdd)
echo OPEND
alter vofs_inn dc = 0.439157907143
alter vdc_inp dc = 0.464873092857
echo SWP 18
op
echo OPSTART
print @m.xm1.msky130_fd_pr__nfet_01v8[id]
print @m.xm1.msky130_fd_pr__nfet_01v8[gm]
print @m.xm1.msky130_fd_pr__nfet_01v8[gds]
print @m.xm1.msky130_fd_pr__nfet_01v8[vth]
print @m.xm1.msky130_fd_pr__nfet_01v8[vdsat]
print @m.xm1.msky130_fd_pr__nfet_01v8[vgs]
print @m.xm1.msky130_fd_pr__nfet_01v8[vds]
print @m.xm1.msky130_fd_pr__nfet_01v8[vbs]
print @m.xm2.msky130_fd_pr__nfet_01v8[id]
print @m.xm2.msky130_fd_pr__nfet_01v8[gm]
print @m.xm2.msky130_fd_pr__nfet_01v8[gds]
print @m.xm2.msky130_fd_pr__nfet_01v8[vth]
print @m.xm2.msky130_fd_pr__nfet_01v8[vdsat]
print @m.xm2.msky130_fd_pr__nfet_01v8[vgs]
print @m.xm2.msky130_fd_pr__nfet_01v8[vds]
print @m.xm2.msky130_fd_pr__nfet_01v8[vbs]
print @m.xm3.msky130_fd_pr__pfet_01v8[id]
print @m.xm3.msky130_fd_pr__pfet_01v8[gm]
print @m.xm3.msky130_fd_pr__pfet_01v8[gds]
print @m.xm3.msky130_fd_pr__pfet_01v8[vth]
print @m.xm3.msky130_fd_pr__pfet_01v8[vdsat]
print @m.xm3.msky130_fd_pr__pfet_01v8[vgs]
print @m.xm3.msky130_fd_pr__pfet_01v8[vds]
print @m.xm3.msky130_fd_pr__pfet_01v8[vbs]
print @m.xm4.msky130_fd_pr__pfet_01v8[id]
print @m.xm4.msky130_fd_pr__pfet_01v8[gm]
print @m.xm4.msky130_fd_pr__pfet_01v8[gds]
print @m.xm4.msky130_fd_pr__pfet_01v8[vth]
print @m.xm4.msky130_fd_pr__pfet_01v8[vdsat]
print @m.xm4.msky130_fd_pr__pfet_01v8[vgs]
print @m.xm4.msky130_fd_pr__pfet_01v8[vds]
print @m.xm4.msky130_fd_pr__pfet_01v8[vbs]
print v(d1)
print v(inp)
print v(tail)
print v(out)
print v(inn)
print v(vdd)
print i(vrail_vdd)
echo OPEND
alter vofs_inn dc = 0.413443621429
alter vdc_inp dc = 0.490587378571
echo SWP 19
op
echo OPSTART
print @m.xm1.msky130_fd_pr__nfet_01v8[id]
print @m.xm1.msky130_fd_pr__nfet_01v8[gm]
print @m.xm1.msky130_fd_pr__nfet_01v8[gds]
print @m.xm1.msky130_fd_pr__nfet_01v8[vth]
print @m.xm1.msky130_fd_pr__nfet_01v8[vdsat]
print @m.xm1.msky130_fd_pr__nfet_01v8[vgs]
print @m.xm1.msky130_fd_pr__nfet_01v8[vds]
print @m.xm1.msky130_fd_pr__nfet_01v8[vbs]
print @m.xm2.msky130_fd_pr__nfet_01v8[id]
print @m.xm2.msky130_fd_pr__nfet_01v8[gm]
print @m.xm2.msky130_fd_pr__nfet_01v8[gds]
print @m.xm2.msky130_fd_pr__nfet_01v8[vth]
print @m.xm2.msky130_fd_pr__nfet_01v8[vdsat]
print @m.xm2.msky130_fd_pr__nfet_01v8[vgs]
print @m.xm2.msky130_fd_pr__nfet_01v8[vds]
print @m.xm2.msky130_fd_pr__nfet_01v8[vbs]
print @m.xm3.msky130_fd_pr__pfet_01v8[id]
print @m.xm3.msky130_fd_pr__pfet_01v8[gm]
print @m.xm3.msky130_fd_pr__pfet_01v8[gds]
print @m.xm3.msky130_fd_pr__pfet_01v8[vth]
print @m.xm3.msky130_fd_pr__pfet_01v8[vdsat]
print @m.xm3.msky130_fd_pr__pfet_01v8[vgs]
print @m.xm3.msky130_fd_pr__pfet_01v8[vds]
print @m.xm3.msky130_fd_pr__pfet_01v8[vbs]
print @m.xm4.msky130_fd_pr__pfet_01v8[id]
print @m.xm4.msky130_fd_pr__pfet_01v8[gm]
print @m.xm4.msky130_fd_pr__pfet_01v8[gds]
print @m.xm4.msky130_fd_pr__pfet_01v8[vth]
print @m.xm4.msky130_fd_pr__pfet_01v8[vdsat]
print @m.xm4.msky130_fd_pr__pfet_01v8[vgs]
print @m.xm4.msky130_fd_pr__pfet_01v8[vds]
print @m.xm4.msky130_fd_pr__pfet_01v8[vbs]
print v(d1)
print v(inp)
print v(tail)
print v(out)
print v(inn)
print v(vdd)
print i(vrail_vdd)
echo OPEND
alter vofs_inn dc = 0.387729335714
alter vdc_inp dc = 0.516301664286
echo SWP 20
op
echo OPSTART
print @m.xm1.msky130_fd_pr__nfet_01v8[id]
print @m.xm1.msky130_fd_pr__nfet_01v8[gm]
print @m.xm1.msky130_fd_pr__nfet_01v8[gds]
print @m.xm1.msky130_fd_pr__nfet_01v8[vth]
print @m.xm1.msky130_fd_pr__nfet_01v8[vdsat]
print @m.xm1.msky130_fd_pr__nfet_01v8[vgs]
print @m.xm1.msky130_fd_pr__nfet_01v8[vds]
print @m.xm1.msky130_fd_pr__nfet_01v8[vbs]
print @m.xm2.msky130_fd_pr__nfet_01v8[id]
print @m.xm2.msky130_fd_pr__nfet_01v8[gm]
print @m.xm2.msky130_fd_pr__nfet_01v8[gds]
print @m.xm2.msky130_fd_pr__nfet_01v8[vth]
print @m.xm2.msky130_fd_pr__nfet_01v8[vdsat]
print @m.xm2.msky130_fd_pr__nfet_01v8[vgs]
print @m.xm2.msky130_fd_pr__nfet_01v8[vds]
print @m.xm2.msky130_fd_pr__nfet_01v8[vbs]
print @m.xm3.msky130_fd_pr__pfet_01v8[id]
print @m.xm3.msky130_fd_pr__pfet_01v8[gm]
print @m.xm3.msky130_fd_pr__pfet_01v8[gds]
print @m.xm3.msky130_fd_pr__pfet_01v8[vth]
print @m.xm3.msky130_fd_pr__pfet_01v8[vdsat]
print @m.xm3.msky130_fd_pr__pfet_01v8[vgs]
print @m.xm3.msky130_fd_pr__pfet_01v8[vds]
print @m.xm3.msky130_fd_pr__pfet_01v8[vbs]
print @m.xm4.msky130_fd_pr__pfet_01v8[id]
print @m.xm4.msky130_fd_pr__pfet_01v8[gm]
print @m.xm4.msky130_fd_pr__pfet_01v8[gds]
print @m.xm4.msky130_fd_pr__pfet_01v8[vth]
print @m.xm4.msky130_fd_pr__pfet_01v8[vdsat]
print @m.xm4.msky130_fd_pr__pfet_01v8[vgs]
print @m.xm4.msky130_fd_pr__pfet_01v8[vds]
print @m.xm4.msky130_fd_pr__pfet_01v8[vbs]
print v(d1)
print v(inp)
print v(tail)
print v(out)
print v(inn)
print v(vdd)
print i(vrail_vdd)
echo OPEND
alter vofs_inn dc = 0.36201505
alter vdc_inp dc = 0.54201595
echo SWP 21
op
echo OPSTART
print @m.xm1.msky130_fd_pr__nfet_01v8[id]
print @m.xm1.msky130_fd_pr__nfet_01v8[gm]
print @m.xm1.msky130_fd_pr__nfet_01v8[gds]
print @m.xm1.msky130_fd_pr__nfet_01v8[vth]
print @m.xm1.msky130_fd_pr__nfet_01v8[vdsat]
print @m.xm1.msky130_fd_pr__nfet_01v8[vgs]
print @m.xm1.msky130_fd_pr__nfet_01v8[vds]
print @m.xm1.msky130_fd_pr__nfet_01v8[vbs]
print @m.xm2.msky130_fd_pr__nfet_01v8[id]
print @m.xm2.msky130_fd_pr__nfet_01v8[gm]
print @m.xm2.msky130_fd_pr__nfet_01v8[gds]
print @m.xm2.msky130_fd_pr__nfet_01v8[vth]
print @m.xm2.msky130_fd_pr__nfet_01v8[vdsat]
print @m.xm2.msky130_fd_pr__nfet_01v8[vgs]
print @m.xm2.msky130_fd_pr__nfet_01v8[vds]
print @m.xm2.msky130_fd_pr__nfet_01v8[vbs]
print @m.xm3.msky130_fd_pr__pfet_01v8[id]
print @m.xm3.msky130_fd_pr__pfet_01v8[gm]
print @m.xm3.msky130_fd_pr__pfet_01v8[gds]
print @m.xm3.msky130_fd_pr__pfet_01v8[vth]
print @m.xm3.msky130_fd_pr__pfet_01v8[vdsat]
print @m.xm3.msky130_fd_pr__pfet_01v8[vgs]
print @m.xm3.msky130_fd_pr__pfet_01v8[vds]
print @m.xm3.msky130_fd_pr__pfet_01v8[vbs]
print @m.xm4.msky130_fd_pr__pfet_01v8[id]
print @m.xm4.msky130_fd_pr__pfet_01v8[gm]
print @m.xm4.msky130_fd_pr__pfet_01v8[gds]
print @m.xm4.msky130_fd_pr__pfet_01v8[vth]
print @m.xm4.msky130_fd_pr__pfet_01v8[vdsat]
print @m.xm4.msky130_fd_pr__pfet_01v8[vgs]
print @m.xm4.msky130_fd_pr__pfet_01v8[vds]
print @m.xm4.msky130_fd_pr__pfet_01v8[vbs]
print v(d1)
print v(inp)
print v(tail)
print v(out)
print v(inn)
print v(vdd)
print i(vrail_vdd)
echo OPEND
alter vofs_inn dc = 0.336300764286
alter vdc_inp dc = 0.567730235714
echo SWP 22
op
echo OPSTART
print @m.xm1.msky130_fd_pr__nfet_01v8[id]
print @m.xm1.msky130_fd_pr__nfet_01v8[gm]
print @m.xm1.msky130_fd_pr__nfet_01v8[gds]
print @m.xm1.msky130_fd_pr__nfet_01v8[vth]
print @m.xm1.msky130_fd_pr__nfet_01v8[vdsat]
print @m.xm1.msky130_fd_pr__nfet_01v8[vgs]
print @m.xm1.msky130_fd_pr__nfet_01v8[vds]
print @m.xm1.msky130_fd_pr__nfet_01v8[vbs]
print @m.xm2.msky130_fd_pr__nfet_01v8[id]
print @m.xm2.msky130_fd_pr__nfet_01v8[gm]
print @m.xm2.msky130_fd_pr__nfet_01v8[gds]
print @m.xm2.msky130_fd_pr__nfet_01v8[vth]
print @m.xm2.msky130_fd_pr__nfet_01v8[vdsat]
print @m.xm2.msky130_fd_pr__nfet_01v8[vgs]
print @m.xm2.msky130_fd_pr__nfet_01v8[vds]
print @m.xm2.msky130_fd_pr__nfet_01v8[vbs]
print @m.xm3.msky130_fd_pr__pfet_01v8[id]
print @m.xm3.msky130_fd_pr__pfet_01v8[gm]
print @m.xm3.msky130_fd_pr__pfet_01v8[gds]
print @m.xm3.msky130_fd_pr__pfet_01v8[vth]
print @m.xm3.msky130_fd_pr__pfet_01v8[vdsat]
print @m.xm3.msky130_fd_pr__pfet_01v8[vgs]
print @m.xm3.msky130_fd_pr__pfet_01v8[vds]
print @m.xm3.msky130_fd_pr__pfet_01v8[vbs]
print @m.xm4.msky130_fd_pr__pfet_01v8[id]
print @m.xm4.msky130_fd_pr__pfet_01v8[gm]
print @m.xm4.msky130_fd_pr__pfet_01v8[gds]
print @m.xm4.msky130_fd_pr__pfet_01v8[vth]
print @m.xm4.msky130_fd_pr__pfet_01v8[vdsat]
print @m.xm4.msky130_fd_pr__pfet_01v8[vgs]
print @m.xm4.msky130_fd_pr__pfet_01v8[vds]
print @m.xm4.msky130_fd_pr__pfet_01v8[vbs]
print v(d1)
print v(inp)
print v(tail)
print v(out)
print v(inn)
print v(vdd)
print i(vrail_vdd)
echo OPEND
alter vofs_inn dc = 0.310586478571
alter vdc_inp dc = 0.593444521429
echo SWP 23
op
echo OPSTART
print @m.xm1.msky130_fd_pr__nfet_01v8[id]
print @m.xm1.msky130_fd_pr__nfet_01v8[gm]
print @m.xm1.msky130_fd_pr__nfet_01v8[gds]
print @m.xm1.msky130_fd_pr__nfet_01v8[vth]
print @m.xm1.msky130_fd_pr__nfet_01v8[vdsat]
print @m.xm1.msky130_fd_pr__nfet_01v8[vgs]
print @m.xm1.msky130_fd_pr__nfet_01v8[vds]
print @m.xm1.msky130_fd_pr__nfet_01v8[vbs]
print @m.xm2.msky130_fd_pr__nfet_01v8[id]
print @m.xm2.msky130_fd_pr__nfet_01v8[gm]
print @m.xm2.msky130_fd_pr__nfet_01v8[gds]
print @m.xm2.msky130_fd_pr__nfet_01v8[vth]
print @m.xm2.msky130_fd_pr__nfet_01v8[vdsat]
print @m.xm2.msky130_fd_pr__nfet_01v8[vgs]
print @m.xm2.msky130_fd_pr__nfet_01v8[vds]
print @m.xm2.msky130_fd_pr__nfet_01v8[vbs]
print @m.xm3.msky130_fd_pr__pfet_01v8[id]
print @m.xm3.msky130_fd_pr__pfet_01v8[gm]
print @m.xm3.msky130_fd_pr__pfet_01v8[gds]
print @m.xm3.msky130_fd_pr__pfet_01v8[vth]
print @m.xm3.msky130_fd_pr__pfet_01v8[vdsat]
print @m.xm3.msky130_fd_pr__pfet_01v8[vgs]
print @m.xm3.msky130_fd_pr__pfet_01v8[vds]
print @m.xm3.msky130_fd_pr__pfet_01v8[vbs]
print @m.xm4.msky130_fd_pr__pfet_01v8[id]
print @m.xm4.msky130_fd_pr__pfet_01v8[gm]
print @m.xm4.msky130_fd_pr__pfet_01v8[gds]
print @m.xm4.msky130_fd_pr__pfet_01v8[vth]
print @m.xm4.msky130_fd_pr__pfet_01v8[vdsat]
print @m.xm4.msky130_fd_pr__pfet_01v8[vgs]
print @m.xm4.msky130_fd_pr__pfet_01v8[vds]
print @m.xm4.msky130_fd_pr__pfet_01v8[vbs]
print v(d1)
print v(inp)
print v(tail)
print v(out)
print v(inn)
print v(vdd)
print i(vrail_vdd)
echo OPEND
alter vofs_inn dc = 0.284872192857
alter vdc_inp dc = 0.619158807143
echo SWP 24
op
echo OPSTART
print @m.xm1.msky130_fd_pr__nfet_01v8[id]
print @m.xm1.msky130_fd_pr__nfet_01v8[gm]
print @m.xm1.msky130_fd_pr__nfet_01v8[gds]
print @m.xm1.msky130_fd_pr__nfet_01v8[vth]
print @m.xm1.msky130_fd_pr__nfet_01v8[vdsat]
print @m.xm1.msky130_fd_pr__nfet_01v8[vgs]
print @m.xm1.msky130_fd_pr__nfet_01v8[vds]
print @m.xm1.msky130_fd_pr__nfet_01v8[vbs]
print @m.xm2.msky130_fd_pr__nfet_01v8[id]
print @m.xm2.msky130_fd_pr__nfet_01v8[gm]
print @m.xm2.msky130_fd_pr__nfet_01v8[gds]
print @m.xm2.msky130_fd_pr__nfet_01v8[vth]
print @m.xm2.msky130_fd_pr__nfet_01v8[vdsat]
print @m.xm2.msky130_fd_pr__nfet_01v8[vgs]
print @m.xm2.msky130_fd_pr__nfet_01v8[vds]
print @m.xm2.msky130_fd_pr__nfet_01v8[vbs]
print @m.xm3.msky130_fd_pr__pfet_01v8[id]
print @m.xm3.msky130_fd_pr__pfet_01v8[gm]
print @m.xm3.msky130_fd_pr__pfet_01v8[gds]
print @m.xm3.msky130_fd_pr__pfet_01v8[vth]
print @m.xm3.msky130_fd_pr__pfet_01v8[vdsat]
print @m.xm3.msky130_fd_pr__pfet_01v8[vgs]
print @m.xm3.msky130_fd_pr__pfet_01v8[vds]
print @m.xm3.msky130_fd_pr__pfet_01v8[vbs]
print @m.xm4.msky130_fd_pr__pfet_01v8[id]
print @m.xm4.msky130_fd_pr__pfet_01v8[gm]
print @m.xm4.msky130_fd_pr__pfet_01v8[gds]
print @m.xm4.msky130_fd_pr__pfet_01v8[vth]
print @m.xm4.msky130_fd_pr__pfet_01v8[vdsat]
print @m.xm4.msky130_fd_pr__pfet_01v8[vgs]
print @m.xm4.msky130_fd_pr__pfet_01v8[vds]
print @m.xm4.msky130_fd_pr__pfet_01v8[vbs]
print v(d1)
print v(inp)
print v(tail)
print v(out)
print v(inn)
print v(vdd)
print i(vrail_vdd)
echo OPEND
alter vofs_inn dc = 0.259157907143
alter vdc_inp dc = 0.644873092857
echo SWP 25
op
echo OPSTART
print @m.xm1.msky130_fd_pr__nfet_01v8[id]
print @m.xm1.msky130_fd_pr__nfet_01v8[gm]
print @m.xm1.msky130_fd_pr__nfet_01v8[gds]
print @m.xm1.msky130_fd_pr__nfet_01v8[vth]
print @m.xm1.msky130_fd_pr__nfet_01v8[vdsat]
print @m.xm1.msky130_fd_pr__nfet_01v8[vgs]
print @m.xm1.msky130_fd_pr__nfet_01v8[vds]
print @m.xm1.msky130_fd_pr__nfet_01v8[vbs]
print @m.xm2.msky130_fd_pr__nfet_01v8[id]
print @m.xm2.msky130_fd_pr__nfet_01v8[gm]
print @m.xm2.msky130_fd_pr__nfet_01v8[gds]
print @m.xm2.msky130_fd_pr__nfet_01v8[vth]
print @m.xm2.msky130_fd_pr__nfet_01v8[vdsat]
print @m.xm2.msky130_fd_pr__nfet_01v8[vgs]
print @m.xm2.msky130_fd_pr__nfet_01v8[vds]
print @m.xm2.msky130_fd_pr__nfet_01v8[vbs]
print @m.xm3.msky130_fd_pr__pfet_01v8[id]
print @m.xm3.msky130_fd_pr__pfet_01v8[gm]
print @m.xm3.msky130_fd_pr__pfet_01v8[gds]
print @m.xm3.msky130_fd_pr__pfet_01v8[vth]
print @m.xm3.msky130_fd_pr__pfet_01v8[vdsat]
print @m.xm3.msky130_fd_pr__pfet_01v8[vgs]
print @m.xm3.msky130_fd_pr__pfet_01v8[vds]
print @m.xm3.msky130_fd_pr__pfet_01v8[vbs]
print @m.xm4.msky130_fd_pr__pfet_01v8[id]
print @m.xm4.msky130_fd_pr__pfet_01v8[gm]
print @m.xm4.msky130_fd_pr__pfet_01v8[gds]
print @m.xm4.msky130_fd_pr__pfet_01v8[vth]
print @m.xm4.msky130_fd_pr__pfet_01v8[vdsat]
print @m.xm4.msky130_fd_pr__pfet_01v8[vgs]
print @m.xm4.msky130_fd_pr__pfet_01v8[vds]
print @m.xm4.msky130_fd_pr__pfet_01v8[vbs]
print v(d1)
print v(inp)
print v(tail)
print v(out)
print v(inn)
print v(vdd)
print i(vrail_vdd)
echo OPEND
alter vofs_inn dc = 0.233443621429
alter vdc_inp dc = 0.670587378571
echo SWP 26
op
echo OPSTART
print @m.xm1.msky130_fd_pr__nfet_01v8[id]
print @m.xm1.msky130_fd_pr__nfet_01v8[gm]
print @m.xm1.msky130_fd_pr__nfet_01v8[gds]
print @m.xm1.msky130_fd_pr__nfet_01v8[vth]
print @m.xm1.msky130_fd_pr__nfet_01v8[vdsat]
print @m.xm1.msky130_fd_pr__nfet_01v8[vgs]
print @m.xm1.msky130_fd_pr__nfet_01v8[vds]
print @m.xm1.msky130_fd_pr__nfet_01v8[vbs]
print @m.xm2.msky130_fd_pr__nfet_01v8[id]
print @m.xm2.msky130_fd_pr__nfet_01v8[gm]
print @m.xm2.msky130_fd_pr__nfet_01v8[gds]
print @m.xm2.msky130_fd_pr__nfet_01v8[vth]
print @m.xm2.msky130_fd_pr__nfet_01v8[vdsat]
print @m.xm2.msky130_fd_pr__nfet_01v8[vgs]
print @m.xm2.msky130_fd_pr__nfet_01v8[vds]
print @m.xm2.msky130_fd_pr__nfet_01v8[vbs]
print @m.xm3.msky130_fd_pr__pfet_01v8[id]
print @m.xm3.msky130_fd_pr__pfet_01v8[gm]
print @m.xm3.msky130_fd_pr__pfet_01v8[gds]
print @m.xm3.msky130_fd_pr__pfet_01v8[vth]
print @m.xm3.msky130_fd_pr__pfet_01v8[vdsat]
print @m.xm3.msky130_fd_pr__pfet_01v8[vgs]
print @m.xm3.msky130_fd_pr__pfet_01v8[vds]
print @m.xm3.msky130_fd_pr__pfet_01v8[vbs]
print @m.xm4.msky130_fd_pr__pfet_01v8[id]
print @m.xm4.msky130_fd_pr__pfet_01v8[gm]
print @m.xm4.msky130_fd_pr__pfet_01v8[gds]
print @m.xm4.msky130_fd_pr__pfet_01v8[vth]
print @m.xm4.msky130_fd_pr__pfet_01v8[vdsat]
print @m.xm4.msky130_fd_pr__pfet_01v8[vgs]
print @m.xm4.msky130_fd_pr__pfet_01v8[vds]
print @m.xm4.msky130_fd_pr__pfet_01v8[vbs]
print v(d1)
print v(inp)
print v(tail)
print v(out)
print v(inn)
print v(vdd)
print i(vrail_vdd)
echo OPEND
alter vofs_inn dc = 0.207729335714
alter vdc_inp dc = 0.696301664286
echo SWP 27
op
echo OPSTART
print @m.xm1.msky130_fd_pr__nfet_01v8[id]
print @m.xm1.msky130_fd_pr__nfet_01v8[gm]
print @m.xm1.msky130_fd_pr__nfet_01v8[gds]
print @m.xm1.msky130_fd_pr__nfet_01v8[vth]
print @m.xm1.msky130_fd_pr__nfet_01v8[vdsat]
print @m.xm1.msky130_fd_pr__nfet_01v8[vgs]
print @m.xm1.msky130_fd_pr__nfet_01v8[vds]
print @m.xm1.msky130_fd_pr__nfet_01v8[vbs]
print @m.xm2.msky130_fd_pr__nfet_01v8[id]
print @m.xm2.msky130_fd_pr__nfet_01v8[gm]
print @m.xm2.msky130_fd_pr__nfet_01v8[gds]
print @m.xm2.msky130_fd_pr__nfet_01v8[vth]
print @m.xm2.msky130_fd_pr__nfet_01v8[vdsat]
print @m.xm2.msky130_fd_pr__nfet_01v8[vgs]
print @m.xm2.msky130_fd_pr__nfet_01v8[vds]
print @m.xm2.msky130_fd_pr__nfet_01v8[vbs]
print @m.xm3.msky130_fd_pr__pfet_01v8[id]
print @m.xm3.msky130_fd_pr__pfet_01v8[gm]
print @m.xm3.msky130_fd_pr__pfet_01v8[gds]
print @m.xm3.msky130_fd_pr__pfet_01v8[vth]
print @m.xm3.msky130_fd_pr__pfet_01v8[vdsat]
print @m.xm3.msky130_fd_pr__pfet_01v8[vgs]
print @m.xm3.msky130_fd_pr__pfet_01v8[vds]
print @m.xm3.msky130_fd_pr__pfet_01v8[vbs]
print @m.xm4.msky130_fd_pr__pfet_01v8[id]
print @m.xm4.msky130_fd_pr__pfet_01v8[gm]
print @m.xm4.msky130_fd_pr__pfet_01v8[gds]
print @m.xm4.msky130_fd_pr__pfet_01v8[vth]
print @m.xm4.msky130_fd_pr__pfet_01v8[vdsat]
print @m.xm4.msky130_fd_pr__pfet_01v8[vgs]
print @m.xm4.msky130_fd_pr__pfet_01v8[vds]
print @m.xm4.msky130_fd_pr__pfet_01v8[vbs]
print v(d1)
print v(inp)
print v(tail)
print v(out)
print v(inn)
print v(vdd)
print i(vrail_vdd)
echo OPEND
alter vofs_inn dc = 0.18201505
alter vdc_inp dc = 0.72201595
echo SWP 28
op
echo OPSTART
print @m.xm1.msky130_fd_pr__nfet_01v8[id]
print @m.xm1.msky130_fd_pr__nfet_01v8[gm]
print @m.xm1.msky130_fd_pr__nfet_01v8[gds]
print @m.xm1.msky130_fd_pr__nfet_01v8[vth]
print @m.xm1.msky130_fd_pr__nfet_01v8[vdsat]
print @m.xm1.msky130_fd_pr__nfet_01v8[vgs]
print @m.xm1.msky130_fd_pr__nfet_01v8[vds]
print @m.xm1.msky130_fd_pr__nfet_01v8[vbs]
print @m.xm2.msky130_fd_pr__nfet_01v8[id]
print @m.xm2.msky130_fd_pr__nfet_01v8[gm]
print @m.xm2.msky130_fd_pr__nfet_01v8[gds]
print @m.xm2.msky130_fd_pr__nfet_01v8[vth]
print @m.xm2.msky130_fd_pr__nfet_01v8[vdsat]
print @m.xm2.msky130_fd_pr__nfet_01v8[vgs]
print @m.xm2.msky130_fd_pr__nfet_01v8[vds]
print @m.xm2.msky130_fd_pr__nfet_01v8[vbs]
print @m.xm3.msky130_fd_pr__pfet_01v8[id]
print @m.xm3.msky130_fd_pr__pfet_01v8[gm]
print @m.xm3.msky130_fd_pr__pfet_01v8[gds]
print @m.xm3.msky130_fd_pr__pfet_01v8[vth]
print @m.xm3.msky130_fd_pr__pfet_01v8[vdsat]
print @m.xm3.msky130_fd_pr__pfet_01v8[vgs]
print @m.xm3.msky130_fd_pr__pfet_01v8[vds]
print @m.xm3.msky130_fd_pr__pfet_01v8[vbs]
print @m.xm4.msky130_fd_pr__pfet_01v8[id]
print @m.xm4.msky130_fd_pr__pfet_01v8[gm]
print @m.xm4.msky130_fd_pr__pfet_01v8[gds]
print @m.xm4.msky130_fd_pr__pfet_01v8[vth]
print @m.xm4.msky130_fd_pr__pfet_01v8[vdsat]
print @m.xm4.msky130_fd_pr__pfet_01v8[vgs]
print @m.xm4.msky130_fd_pr__pfet_01v8[vds]
print @m.xm4.msky130_fd_pr__pfet_01v8[vbs]
print v(d1)
print v(inp)
print v(tail)
print v(out)
print v(inn)
print v(vdd)
print i(vrail_vdd)
echo OPEND
alter vofs_inn dc = 0.156300764286
alter vdc_inp dc = 0.747730235714
echo SWP 29
op
echo OPSTART
print @m.xm1.msky130_fd_pr__nfet_01v8[id]
print @m.xm1.msky130_fd_pr__nfet_01v8[gm]
print @m.xm1.msky130_fd_pr__nfet_01v8[gds]
print @m.xm1.msky130_fd_pr__nfet_01v8[vth]
print @m.xm1.msky130_fd_pr__nfet_01v8[vdsat]
print @m.xm1.msky130_fd_pr__nfet_01v8[vgs]
print @m.xm1.msky130_fd_pr__nfet_01v8[vds]
print @m.xm1.msky130_fd_pr__nfet_01v8[vbs]
print @m.xm2.msky130_fd_pr__nfet_01v8[id]
print @m.xm2.msky130_fd_pr__nfet_01v8[gm]
print @m.xm2.msky130_fd_pr__nfet_01v8[gds]
print @m.xm2.msky130_fd_pr__nfet_01v8[vth]
print @m.xm2.msky130_fd_pr__nfet_01v8[vdsat]
print @m.xm2.msky130_fd_pr__nfet_01v8[vgs]
print @m.xm2.msky130_fd_pr__nfet_01v8[vds]
print @m.xm2.msky130_fd_pr__nfet_01v8[vbs]
print @m.xm3.msky130_fd_pr__pfet_01v8[id]
print @m.xm3.msky130_fd_pr__pfet_01v8[gm]
print @m.xm3.msky130_fd_pr__pfet_01v8[gds]
print @m.xm3.msky130_fd_pr__pfet_01v8[vth]
print @m.xm3.msky130_fd_pr__pfet_01v8[vdsat]
print @m.xm3.msky130_fd_pr__pfet_01v8[vgs]
print @m.xm3.msky130_fd_pr__pfet_01v8[vds]
print @m.xm3.msky130_fd_pr__pfet_01v8[vbs]
print @m.xm4.msky130_fd_pr__pfet_01v8[id]
print @m.xm4.msky130_fd_pr__pfet_01v8[gm]
print @m.xm4.msky130_fd_pr__pfet_01v8[gds]
print @m.xm4.msky130_fd_pr__pfet_01v8[vth]
print @m.xm4.msky130_fd_pr__pfet_01v8[vdsat]
print @m.xm4.msky130_fd_pr__pfet_01v8[vgs]
print @m.xm4.msky130_fd_pr__pfet_01v8[vds]
print @m.xm4.msky130_fd_pr__pfet_01v8[vbs]
print v(d1)
print v(inp)
print v(tail)
print v(out)
print v(inn)
print v(vdd)
print i(vrail_vdd)
echo OPEND
alter vofs_inn dc = 0.130586478571
alter vdc_inp dc = 0.773444521429
echo SWP 30
op
echo OPSTART
print @m.xm1.msky130_fd_pr__nfet_01v8[id]
print @m.xm1.msky130_fd_pr__nfet_01v8[gm]
print @m.xm1.msky130_fd_pr__nfet_01v8[gds]
print @m.xm1.msky130_fd_pr__nfet_01v8[vth]
print @m.xm1.msky130_fd_pr__nfet_01v8[vdsat]
print @m.xm1.msky130_fd_pr__nfet_01v8[vgs]
print @m.xm1.msky130_fd_pr__nfet_01v8[vds]
print @m.xm1.msky130_fd_pr__nfet_01v8[vbs]
print @m.xm2.msky130_fd_pr__nfet_01v8[id]
print @m.xm2.msky130_fd_pr__nfet_01v8[gm]
print @m.xm2.msky130_fd_pr__nfet_01v8[gds]
print @m.xm2.msky130_fd_pr__nfet_01v8[vth]
print @m.xm2.msky130_fd_pr__nfet_01v8[vdsat]
print @m.xm2.msky130_fd_pr__nfet_01v8[vgs]
print @m.xm2.msky130_fd_pr__nfet_01v8[vds]
print @m.xm2.msky130_fd_pr__nfet_01v8[vbs]
print @m.xm3.msky130_fd_pr__pfet_01v8[id]
print @m.xm3.msky130_fd_pr__pfet_01v8[gm]
print @m.xm3.msky130_fd_pr__pfet_01v8[gds]
print @m.xm3.msky130_fd_pr__pfet_01v8[vth]
print @m.xm3.msky130_fd_pr__pfet_01v8[vdsat]
print @m.xm3.msky130_fd_pr__pfet_01v8[vgs]
print @m.xm3.msky130_fd_pr__pfet_01v8[vds]
print @m.xm3.msky130_fd_pr__pfet_01v8[vbs]
print @m.xm4.msky130_fd_pr__pfet_01v8[id]
print @m.xm4.msky130_fd_pr__pfet_01v8[gm]
print @m.xm4.msky130_fd_pr__pfet_01v8[gds]
print @m.xm4.msky130_fd_pr__pfet_01v8[vth]
print @m.xm4.msky130_fd_pr__pfet_01v8[vdsat]
print @m.xm4.msky130_fd_pr__pfet_01v8[vgs]
print @m.xm4.msky130_fd_pr__pfet_01v8[vds]
print @m.xm4.msky130_fd_pr__pfet_01v8[vbs]
print v(d1)
print v(inp)
print v(tail)
print v(out)
print v(inn)
print v(vdd)
print i(vrail_vdd)
echo OPEND
alter vofs_inn dc = 0.104872192857
alter vdc_inp dc = 0.799158807143
echo SWP 31
op
echo OPSTART
print @m.xm1.msky130_fd_pr__nfet_01v8[id]
print @m.xm1.msky130_fd_pr__nfet_01v8[gm]
print @m.xm1.msky130_fd_pr__nfet_01v8[gds]
print @m.xm1.msky130_fd_pr__nfet_01v8[vth]
print @m.xm1.msky130_fd_pr__nfet_01v8[vdsat]
print @m.xm1.msky130_fd_pr__nfet_01v8[vgs]
print @m.xm1.msky130_fd_pr__nfet_01v8[vds]
print @m.xm1.msky130_fd_pr__nfet_01v8[vbs]
print @m.xm2.msky130_fd_pr__nfet_01v8[id]
print @m.xm2.msky130_fd_pr__nfet_01v8[gm]
print @m.xm2.msky130_fd_pr__nfet_01v8[gds]
print @m.xm2.msky130_fd_pr__nfet_01v8[vth]
print @m.xm2.msky130_fd_pr__nfet_01v8[vdsat]
print @m.xm2.msky130_fd_pr__nfet_01v8[vgs]
print @m.xm2.msky130_fd_pr__nfet_01v8[vds]
print @m.xm2.msky130_fd_pr__nfet_01v8[vbs]
print @m.xm3.msky130_fd_pr__pfet_01v8[id]
print @m.xm3.msky130_fd_pr__pfet_01v8[gm]
print @m.xm3.msky130_fd_pr__pfet_01v8[gds]
print @m.xm3.msky130_fd_pr__pfet_01v8[vth]
print @m.xm3.msky130_fd_pr__pfet_01v8[vdsat]
print @m.xm3.msky130_fd_pr__pfet_01v8[vgs]
print @m.xm3.msky130_fd_pr__pfet_01v8[vds]
print @m.xm3.msky130_fd_pr__pfet_01v8[vbs]
print @m.xm4.msky130_fd_pr__pfet_01v8[id]
print @m.xm4.msky130_fd_pr__pfet_01v8[gm]
print @m.xm4.msky130_fd_pr__pfet_01v8[gds]
print @m.xm4.msky130_fd_pr__pfet_01v8[vth]
print @m.xm4.msky130_fd_pr__pfet_01v8[vdsat]
print @m.xm4.msky130_fd_pr__pfet_01v8[vgs]
print @m.xm4.msky130_fd_pr__pfet_01v8[vds]
print @m.xm4.msky130_fd_pr__pfet_01v8[vbs]
print v(d1)
print v(inp)
print v(tail)
print v(out)
print v(inn)
print v(vdd)
print i(vrail_vdd)
echo OPEND
alter vofs_inn dc = 0.0791579071429
alter vdc_inp dc = 0.824873092857
echo SWP 32
op
echo OPSTART
print @m.xm1.msky130_fd_pr__nfet_01v8[id]
print @m.xm1.msky130_fd_pr__nfet_01v8[gm]
print @m.xm1.msky130_fd_pr__nfet_01v8[gds]
print @m.xm1.msky130_fd_pr__nfet_01v8[vth]
print @m.xm1.msky130_fd_pr__nfet_01v8[vdsat]
print @m.xm1.msky130_fd_pr__nfet_01v8[vgs]
print @m.xm1.msky130_fd_pr__nfet_01v8[vds]
print @m.xm1.msky130_fd_pr__nfet_01v8[vbs]
print @m.xm2.msky130_fd_pr__nfet_01v8[id]
print @m.xm2.msky130_fd_pr__nfet_01v8[gm]
print @m.xm2.msky130_fd_pr__nfet_01v8[gds]
print @m.xm2.msky130_fd_pr__nfet_01v8[vth]
print @m.xm2.msky130_fd_pr__nfet_01v8[vdsat]
print @m.xm2.msky130_fd_pr__nfet_01v8[vgs]
print @m.xm2.msky130_fd_pr__nfet_01v8[vds]
print @m.xm2.msky130_fd_pr__nfet_01v8[vbs]
print @m.xm3.msky130_fd_pr__pfet_01v8[id]
print @m.xm3.msky130_fd_pr__pfet_01v8[gm]
print @m.xm3.msky130_fd_pr__pfet_01v8[gds]
print @m.xm3.msky130_fd_pr__pfet_01v8[vth]
print @m.xm3.msky130_fd_pr__pfet_01v8[vdsat]
print @m.xm3.msky130_fd_pr__pfet_01v8[vgs]
print @m.xm3.msky130_fd_pr__pfet_01v8[vds]
print @m.xm3.msky130_fd_pr__pfet_01v8[vbs]
print @m.xm4.msky130_fd_pr__pfet_01v8[id]
print @m.xm4.msky130_fd_pr__pfet_01v8[gm]
print @m.xm4.msky130_fd_pr__pfet_01v8[gds]
print @m.xm4.msky130_fd_pr__pfet_01v8[vth]
print @m.xm4.msky130_fd_pr__pfet_01v8[vdsat]
print @m.xm4.msky130_fd_pr__pfet_01v8[vgs]
print @m.xm4.msky130_fd_pr__pfet_01v8[vds]
print @m.xm4.msky130_fd_pr__pfet_01v8[vbs]
print v(d1)
print v(inp)
print v(tail)
print v(out)
print v(inn)
print v(vdd)
print i(vrail_vdd)
echo OPEND
alter vofs_inn dc = 0.0534436214286
alter vdc_inp dc = 0.850587378571
echo SWP 33
op
echo OPSTART
print @m.xm1.msky130_fd_pr__nfet_01v8[id]
print @m.xm1.msky130_fd_pr__nfet_01v8[gm]
print @m.xm1.msky130_fd_pr__nfet_01v8[gds]
print @m.xm1.msky130_fd_pr__nfet_01v8[vth]
print @m.xm1.msky130_fd_pr__nfet_01v8[vdsat]
print @m.xm1.msky130_fd_pr__nfet_01v8[vgs]
print @m.xm1.msky130_fd_pr__nfet_01v8[vds]
print @m.xm1.msky130_fd_pr__nfet_01v8[vbs]
print @m.xm2.msky130_fd_pr__nfet_01v8[id]
print @m.xm2.msky130_fd_pr__nfet_01v8[gm]
print @m.xm2.msky130_fd_pr__nfet_01v8[gds]
print @m.xm2.msky130_fd_pr__nfet_01v8[vth]
print @m.xm2.msky130_fd_pr__nfet_01v8[vdsat]
print @m.xm2.msky130_fd_pr__nfet_01v8[vgs]
print @m.xm2.msky130_fd_pr__nfet_01v8[vds]
print @m.xm2.msky130_fd_pr__nfet_01v8[vbs]
print @m.xm3.msky130_fd_pr__pfet_01v8[id]
print @m.xm3.msky130_fd_pr__pfet_01v8[gm]
print @m.xm3.msky130_fd_pr__pfet_01v8[gds]
print @m.xm3.msky130_fd_pr__pfet_01v8[vth]
print @m.xm3.msky130_fd_pr__pfet_01v8[vdsat]
print @m.xm3.msky130_fd_pr__pfet_01v8[vgs]
print @m.xm3.msky130_fd_pr__pfet_01v8[vds]
print @m.xm3.msky130_fd_pr__pfet_01v8[vbs]
print @m.xm4.msky130_fd_pr__pfet_01v8[id]
print @m.xm4.msky130_fd_pr__pfet_01v8[gm]
print @m.xm4.msky130_fd_pr__pfet_01v8[gds]
print @m.xm4.msky130_fd_pr__pfet_01v8[vth]
print @m.xm4.msky130_fd_pr__pfet_01v8[vdsat]
print @m.xm4.msky130_fd_pr__pfet_01v8[vgs]
print @m.xm4.msky130_fd_pr__pfet_01v8[vds]
print @m.xm4.msky130_fd_pr__pfet_01v8[vbs]
print v(d1)
print v(inp)
print v(tail)
print v(out)
print v(inn)
print v(vdd)
print i(vrail_vdd)
echo OPEND
alter vofs_inn dc = 0.0277293357143
alter vdc_inp dc = 0.876301664286
echo SWP 34
op
echo OPSTART
print @m.xm1.msky130_fd_pr__nfet_01v8[id]
print @m.xm1.msky130_fd_pr__nfet_01v8[gm]
print @m.xm1.msky130_fd_pr__nfet_01v8[gds]
print @m.xm1.msky130_fd_pr__nfet_01v8[vth]
print @m.xm1.msky130_fd_pr__nfet_01v8[vdsat]
print @m.xm1.msky130_fd_pr__nfet_01v8[vgs]
print @m.xm1.msky130_fd_pr__nfet_01v8[vds]
print @m.xm1.msky130_fd_pr__nfet_01v8[vbs]
print @m.xm2.msky130_fd_pr__nfet_01v8[id]
print @m.xm2.msky130_fd_pr__nfet_01v8[gm]
print @m.xm2.msky130_fd_pr__nfet_01v8[gds]
print @m.xm2.msky130_fd_pr__nfet_01v8[vth]
print @m.xm2.msky130_fd_pr__nfet_01v8[vdsat]
print @m.xm2.msky130_fd_pr__nfet_01v8[vgs]
print @m.xm2.msky130_fd_pr__nfet_01v8[vds]
print @m.xm2.msky130_fd_pr__nfet_01v8[vbs]
print @m.xm3.msky130_fd_pr__pfet_01v8[id]
print @m.xm3.msky130_fd_pr__pfet_01v8[gm]
print @m.xm3.msky130_fd_pr__pfet_01v8[gds]
print @m.xm3.msky130_fd_pr__pfet_01v8[vth]
print @m.xm3.msky130_fd_pr__pfet_01v8[vdsat]
print @m.xm3.msky130_fd_pr__pfet_01v8[vgs]
print @m.xm3.msky130_fd_pr__pfet_01v8[vds]
print @m.xm3.msky130_fd_pr__pfet_01v8[vbs]
print @m.xm4.msky130_fd_pr__pfet_01v8[id]
print @m.xm4.msky130_fd_pr__pfet_01v8[gm]
print @m.xm4.msky130_fd_pr__pfet_01v8[gds]
print @m.xm4.msky130_fd_pr__pfet_01v8[vth]
print @m.xm4.msky130_fd_pr__pfet_01v8[vdsat]
print @m.xm4.msky130_fd_pr__pfet_01v8[vgs]
print @m.xm4.msky130_fd_pr__pfet_01v8[vds]
print @m.xm4.msky130_fd_pr__pfet_01v8[vbs]
print v(d1)
print v(inp)
print v(tail)
print v(out)
print v(inn)
print v(vdd)
print i(vrail_vdd)
echo OPEND
alter vofs_inn dc = 0.004031
alter vdc_inp dc = 0.9
echo SWP 35
op
echo OPSTART
print @m.xm1.msky130_fd_pr__nfet_01v8[id]
print @m.xm1.msky130_fd_pr__nfet_01v8[gm]
print @m.xm1.msky130_fd_pr__nfet_01v8[gds]
print @m.xm1.msky130_fd_pr__nfet_01v8[vth]
print @m.xm1.msky130_fd_pr__nfet_01v8[vdsat]
print @m.xm1.msky130_fd_pr__nfet_01v8[vgs]
print @m.xm1.msky130_fd_pr__nfet_01v8[vds]
print @m.xm1.msky130_fd_pr__nfet_01v8[vbs]
print @m.xm2.msky130_fd_pr__nfet_01v8[id]
print @m.xm2.msky130_fd_pr__nfet_01v8[gm]
print @m.xm2.msky130_fd_pr__nfet_01v8[gds]
print @m.xm2.msky130_fd_pr__nfet_01v8[vth]
print @m.xm2.msky130_fd_pr__nfet_01v8[vdsat]
print @m.xm2.msky130_fd_pr__nfet_01v8[vgs]
print @m.xm2.msky130_fd_pr__nfet_01v8[vds]
print @m.xm2.msky130_fd_pr__nfet_01v8[vbs]
print @m.xm3.msky130_fd_pr__pfet_01v8[id]
print @m.xm3.msky130_fd_pr__pfet_01v8[gm]
print @m.xm3.msky130_fd_pr__pfet_01v8[gds]
print @m.xm3.msky130_fd_pr__pfet_01v8[vth]
print @m.xm3.msky130_fd_pr__pfet_01v8[vdsat]
print @m.xm3.msky130_fd_pr__pfet_01v8[vgs]
print @m.xm3.msky130_fd_pr__pfet_01v8[vds]
print @m.xm3.msky130_fd_pr__pfet_01v8[vbs]
print @m.xm4.msky130_fd_pr__pfet_01v8[id]
print @m.xm4.msky130_fd_pr__pfet_01v8[gm]
print @m.xm4.msky130_fd_pr__pfet_01v8[gds]
print @m.xm4.msky130_fd_pr__pfet_01v8[vth]
print @m.xm4.msky130_fd_pr__pfet_01v8[vdsat]
print @m.xm4.msky130_fd_pr__pfet_01v8[vgs]
print @m.xm4.msky130_fd_pr__pfet_01v8[vds]
print @m.xm4.msky130_fd_pr__pfet_01v8[vbs]
print v(d1)
print v(inp)
print v(tail)
print v(out)
print v(inn)
print v(vdd)
print i(vrail_vdd)
echo OPEND
alter vofs_inn dc = 0.00201505
alter vdc_inp dc = 0.90201595
echo SWP 36
op
echo OPSTART
print @m.xm1.msky130_fd_pr__nfet_01v8[id]
print @m.xm1.msky130_fd_pr__nfet_01v8[gm]
print @m.xm1.msky130_fd_pr__nfet_01v8[gds]
print @m.xm1.msky130_fd_pr__nfet_01v8[vth]
print @m.xm1.msky130_fd_pr__nfet_01v8[vdsat]
print @m.xm1.msky130_fd_pr__nfet_01v8[vgs]
print @m.xm1.msky130_fd_pr__nfet_01v8[vds]
print @m.xm1.msky130_fd_pr__nfet_01v8[vbs]
print @m.xm2.msky130_fd_pr__nfet_01v8[id]
print @m.xm2.msky130_fd_pr__nfet_01v8[gm]
print @m.xm2.msky130_fd_pr__nfet_01v8[gds]
print @m.xm2.msky130_fd_pr__nfet_01v8[vth]
print @m.xm2.msky130_fd_pr__nfet_01v8[vdsat]
print @m.xm2.msky130_fd_pr__nfet_01v8[vgs]
print @m.xm2.msky130_fd_pr__nfet_01v8[vds]
print @m.xm2.msky130_fd_pr__nfet_01v8[vbs]
print @m.xm3.msky130_fd_pr__pfet_01v8[id]
print @m.xm3.msky130_fd_pr__pfet_01v8[gm]
print @m.xm3.msky130_fd_pr__pfet_01v8[gds]
print @m.xm3.msky130_fd_pr__pfet_01v8[vth]
print @m.xm3.msky130_fd_pr__pfet_01v8[vdsat]
print @m.xm3.msky130_fd_pr__pfet_01v8[vgs]
print @m.xm3.msky130_fd_pr__pfet_01v8[vds]
print @m.xm3.msky130_fd_pr__pfet_01v8[vbs]
print @m.xm4.msky130_fd_pr__pfet_01v8[id]
print @m.xm4.msky130_fd_pr__pfet_01v8[gm]
print @m.xm4.msky130_fd_pr__pfet_01v8[gds]
print @m.xm4.msky130_fd_pr__pfet_01v8[vth]
print @m.xm4.msky130_fd_pr__pfet_01v8[vdsat]
print @m.xm4.msky130_fd_pr__pfet_01v8[vgs]
print @m.xm4.msky130_fd_pr__pfet_01v8[vds]
print @m.xm4.msky130_fd_pr__pfet_01v8[vbs]
print v(d1)
print v(inp)
print v(tail)
print v(out)
print v(inn)
print v(vdd)
print i(vrail_vdd)
echo OPEND
alter vofs_inn dc = -0.0236992357143
alter vdc_inp dc = 0.927730235714
echo SWP 37
op
echo OPSTART
print @m.xm1.msky130_fd_pr__nfet_01v8[id]
print @m.xm1.msky130_fd_pr__nfet_01v8[gm]
print @m.xm1.msky130_fd_pr__nfet_01v8[gds]
print @m.xm1.msky130_fd_pr__nfet_01v8[vth]
print @m.xm1.msky130_fd_pr__nfet_01v8[vdsat]
print @m.xm1.msky130_fd_pr__nfet_01v8[vgs]
print @m.xm1.msky130_fd_pr__nfet_01v8[vds]
print @m.xm1.msky130_fd_pr__nfet_01v8[vbs]
print @m.xm2.msky130_fd_pr__nfet_01v8[id]
print @m.xm2.msky130_fd_pr__nfet_01v8[gm]
print @m.xm2.msky130_fd_pr__nfet_01v8[gds]
print @m.xm2.msky130_fd_pr__nfet_01v8[vth]
print @m.xm2.msky130_fd_pr__nfet_01v8[vdsat]
print @m.xm2.msky130_fd_pr__nfet_01v8[vgs]
print @m.xm2.msky130_fd_pr__nfet_01v8[vds]
print @m.xm2.msky130_fd_pr__nfet_01v8[vbs]
print @m.xm3.msky130_fd_pr__pfet_01v8[id]
print @m.xm3.msky130_fd_pr__pfet_01v8[gm]
print @m.xm3.msky130_fd_pr__pfet_01v8[gds]
print @m.xm3.msky130_fd_pr__pfet_01v8[vth]
print @m.xm3.msky130_fd_pr__pfet_01v8[vdsat]
print @m.xm3.msky130_fd_pr__pfet_01v8[vgs]
print @m.xm3.msky130_fd_pr__pfet_01v8[vds]
print @m.xm3.msky130_fd_pr__pfet_01v8[vbs]
print @m.xm4.msky130_fd_pr__pfet_01v8[id]
print @m.xm4.msky130_fd_pr__pfet_01v8[gm]
print @m.xm4.msky130_fd_pr__pfet_01v8[gds]
print @m.xm4.msky130_fd_pr__pfet_01v8[vth]
print @m.xm4.msky130_fd_pr__pfet_01v8[vdsat]
print @m.xm4.msky130_fd_pr__pfet_01v8[vgs]
print @m.xm4.msky130_fd_pr__pfet_01v8[vds]
print @m.xm4.msky130_fd_pr__pfet_01v8[vbs]
print v(d1)
print v(inp)
print v(tail)
print v(out)
print v(inn)
print v(vdd)
print i(vrail_vdd)
echo OPEND
alter vofs_inn dc = -0.0494135214286
alter vdc_inp dc = 0.953444521429
echo SWP 38
op
echo OPSTART
print @m.xm1.msky130_fd_pr__nfet_01v8[id]
print @m.xm1.msky130_fd_pr__nfet_01v8[gm]
print @m.xm1.msky130_fd_pr__nfet_01v8[gds]
print @m.xm1.msky130_fd_pr__nfet_01v8[vth]
print @m.xm1.msky130_fd_pr__nfet_01v8[vdsat]
print @m.xm1.msky130_fd_pr__nfet_01v8[vgs]
print @m.xm1.msky130_fd_pr__nfet_01v8[vds]
print @m.xm1.msky130_fd_pr__nfet_01v8[vbs]
print @m.xm2.msky130_fd_pr__nfet_01v8[id]
print @m.xm2.msky130_fd_pr__nfet_01v8[gm]
print @m.xm2.msky130_fd_pr__nfet_01v8[gds]
print @m.xm2.msky130_fd_pr__nfet_01v8[vth]
print @m.xm2.msky130_fd_pr__nfet_01v8[vdsat]
print @m.xm2.msky130_fd_pr__nfet_01v8[vgs]
print @m.xm2.msky130_fd_pr__nfet_01v8[vds]
print @m.xm2.msky130_fd_pr__nfet_01v8[vbs]
print @m.xm3.msky130_fd_pr__pfet_01v8[id]
print @m.xm3.msky130_fd_pr__pfet_01v8[gm]
print @m.xm3.msky130_fd_pr__pfet_01v8[gds]
print @m.xm3.msky130_fd_pr__pfet_01v8[vth]
print @m.xm3.msky130_fd_pr__pfet_01v8[vdsat]
print @m.xm3.msky130_fd_pr__pfet_01v8[vgs]
print @m.xm3.msky130_fd_pr__pfet_01v8[vds]
print @m.xm3.msky130_fd_pr__pfet_01v8[vbs]
print @m.xm4.msky130_fd_pr__pfet_01v8[id]
print @m.xm4.msky130_fd_pr__pfet_01v8[gm]
print @m.xm4.msky130_fd_pr__pfet_01v8[gds]
print @m.xm4.msky130_fd_pr__pfet_01v8[vth]
print @m.xm4.msky130_fd_pr__pfet_01v8[vdsat]
print @m.xm4.msky130_fd_pr__pfet_01v8[vgs]
print @m.xm4.msky130_fd_pr__pfet_01v8[vds]
print @m.xm4.msky130_fd_pr__pfet_01v8[vbs]
print v(d1)
print v(inp)
print v(tail)
print v(out)
print v(inn)
print v(vdd)
print i(vrail_vdd)
echo OPEND
alter vofs_inn dc = -0.0751278071429
alter vdc_inp dc = 0.979158807143
echo SWP 39
op
echo OPSTART
print @m.xm1.msky130_fd_pr__nfet_01v8[id]
print @m.xm1.msky130_fd_pr__nfet_01v8[gm]
print @m.xm1.msky130_fd_pr__nfet_01v8[gds]
print @m.xm1.msky130_fd_pr__nfet_01v8[vth]
print @m.xm1.msky130_fd_pr__nfet_01v8[vdsat]
print @m.xm1.msky130_fd_pr__nfet_01v8[vgs]
print @m.xm1.msky130_fd_pr__nfet_01v8[vds]
print @m.xm1.msky130_fd_pr__nfet_01v8[vbs]
print @m.xm2.msky130_fd_pr__nfet_01v8[id]
print @m.xm2.msky130_fd_pr__nfet_01v8[gm]
print @m.xm2.msky130_fd_pr__nfet_01v8[gds]
print @m.xm2.msky130_fd_pr__nfet_01v8[vth]
print @m.xm2.msky130_fd_pr__nfet_01v8[vdsat]
print @m.xm2.msky130_fd_pr__nfet_01v8[vgs]
print @m.xm2.msky130_fd_pr__nfet_01v8[vds]
print @m.xm2.msky130_fd_pr__nfet_01v8[vbs]
print @m.xm3.msky130_fd_pr__pfet_01v8[id]
print @m.xm3.msky130_fd_pr__pfet_01v8[gm]
print @m.xm3.msky130_fd_pr__pfet_01v8[gds]
print @m.xm3.msky130_fd_pr__pfet_01v8[vth]
print @m.xm3.msky130_fd_pr__pfet_01v8[vdsat]
print @m.xm3.msky130_fd_pr__pfet_01v8[vgs]
print @m.xm3.msky130_fd_pr__pfet_01v8[vds]
print @m.xm3.msky130_fd_pr__pfet_01v8[vbs]
print @m.xm4.msky130_fd_pr__pfet_01v8[id]
print @m.xm4.msky130_fd_pr__pfet_01v8[gm]
print @m.xm4.msky130_fd_pr__pfet_01v8[gds]
print @m.xm4.msky130_fd_pr__pfet_01v8[vth]
print @m.xm4.msky130_fd_pr__pfet_01v8[vdsat]
print @m.xm4.msky130_fd_pr__pfet_01v8[vgs]
print @m.xm4.msky130_fd_pr__pfet_01v8[vds]
print @m.xm4.msky130_fd_pr__pfet_01v8[vbs]
print v(d1)
print v(inp)
print v(tail)
print v(out)
print v(inn)
print v(vdd)
print i(vrail_vdd)
echo OPEND
alter vofs_inn dc = -0.100842092857
alter vdc_inp dc = 1.00487309286
echo SWP 40
op
echo OPSTART
print @m.xm1.msky130_fd_pr__nfet_01v8[id]
print @m.xm1.msky130_fd_pr__nfet_01v8[gm]
print @m.xm1.msky130_fd_pr__nfet_01v8[gds]
print @m.xm1.msky130_fd_pr__nfet_01v8[vth]
print @m.xm1.msky130_fd_pr__nfet_01v8[vdsat]
print @m.xm1.msky130_fd_pr__nfet_01v8[vgs]
print @m.xm1.msky130_fd_pr__nfet_01v8[vds]
print @m.xm1.msky130_fd_pr__nfet_01v8[vbs]
print @m.xm2.msky130_fd_pr__nfet_01v8[id]
print @m.xm2.msky130_fd_pr__nfet_01v8[gm]
print @m.xm2.msky130_fd_pr__nfet_01v8[gds]
print @m.xm2.msky130_fd_pr__nfet_01v8[vth]
print @m.xm2.msky130_fd_pr__nfet_01v8[vdsat]
print @m.xm2.msky130_fd_pr__nfet_01v8[vgs]
print @m.xm2.msky130_fd_pr__nfet_01v8[vds]
print @m.xm2.msky130_fd_pr__nfet_01v8[vbs]
print @m.xm3.msky130_fd_pr__pfet_01v8[id]
print @m.xm3.msky130_fd_pr__pfet_01v8[gm]
print @m.xm3.msky130_fd_pr__pfet_01v8[gds]
print @m.xm3.msky130_fd_pr__pfet_01v8[vth]
print @m.xm3.msky130_fd_pr__pfet_01v8[vdsat]
print @m.xm3.msky130_fd_pr__pfet_01v8[vgs]
print @m.xm3.msky130_fd_pr__pfet_01v8[vds]
print @m.xm3.msky130_fd_pr__pfet_01v8[vbs]
print @m.xm4.msky130_fd_pr__pfet_01v8[id]
print @m.xm4.msky130_fd_pr__pfet_01v8[gm]
print @m.xm4.msky130_fd_pr__pfet_01v8[gds]
print @m.xm4.msky130_fd_pr__pfet_01v8[vth]
print @m.xm4.msky130_fd_pr__pfet_01v8[vdsat]
print @m.xm4.msky130_fd_pr__pfet_01v8[vgs]
print @m.xm4.msky130_fd_pr__pfet_01v8[vds]
print @m.xm4.msky130_fd_pr__pfet_01v8[vbs]
print v(d1)
print v(inp)
print v(tail)
print v(out)
print v(inn)
print v(vdd)
print i(vrail_vdd)
echo OPEND
alter vofs_inn dc = -0.126556378571
alter vdc_inp dc = 1.03058737857
echo SWP 41
op
echo OPSTART
print @m.xm1.msky130_fd_pr__nfet_01v8[id]
print @m.xm1.msky130_fd_pr__nfet_01v8[gm]
print @m.xm1.msky130_fd_pr__nfet_01v8[gds]
print @m.xm1.msky130_fd_pr__nfet_01v8[vth]
print @m.xm1.msky130_fd_pr__nfet_01v8[vdsat]
print @m.xm1.msky130_fd_pr__nfet_01v8[vgs]
print @m.xm1.msky130_fd_pr__nfet_01v8[vds]
print @m.xm1.msky130_fd_pr__nfet_01v8[vbs]
print @m.xm2.msky130_fd_pr__nfet_01v8[id]
print @m.xm2.msky130_fd_pr__nfet_01v8[gm]
print @m.xm2.msky130_fd_pr__nfet_01v8[gds]
print @m.xm2.msky130_fd_pr__nfet_01v8[vth]
print @m.xm2.msky130_fd_pr__nfet_01v8[vdsat]
print @m.xm2.msky130_fd_pr__nfet_01v8[vgs]
print @m.xm2.msky130_fd_pr__nfet_01v8[vds]
print @m.xm2.msky130_fd_pr__nfet_01v8[vbs]
print @m.xm3.msky130_fd_pr__pfet_01v8[id]
print @m.xm3.msky130_fd_pr__pfet_01v8[gm]
print @m.xm3.msky130_fd_pr__pfet_01v8[gds]
print @m.xm3.msky130_fd_pr__pfet_01v8[vth]
print @m.xm3.msky130_fd_pr__pfet_01v8[vdsat]
print @m.xm3.msky130_fd_pr__pfet_01v8[vgs]
print @m.xm3.msky130_fd_pr__pfet_01v8[vds]
print @m.xm3.msky130_fd_pr__pfet_01v8[vbs]
print @m.xm4.msky130_fd_pr__pfet_01v8[id]
print @m.xm4.msky130_fd_pr__pfet_01v8[gm]
print @m.xm4.msky130_fd_pr__pfet_01v8[gds]
print @m.xm4.msky130_fd_pr__pfet_01v8[vth]
print @m.xm4.msky130_fd_pr__pfet_01v8[vdsat]
print @m.xm4.msky130_fd_pr__pfet_01v8[vgs]
print @m.xm4.msky130_fd_pr__pfet_01v8[vds]
print @m.xm4.msky130_fd_pr__pfet_01v8[vbs]
print v(d1)
print v(inp)
print v(tail)
print v(out)
print v(inn)
print v(vdd)
print i(vrail_vdd)
echo OPEND
alter vofs_inn dc = -0.152270664286
alter vdc_inp dc = 1.05630166429
echo SWP 42
op
echo OPSTART
print @m.xm1.msky130_fd_pr__nfet_01v8[id]
print @m.xm1.msky130_fd_pr__nfet_01v8[gm]
print @m.xm1.msky130_fd_pr__nfet_01v8[gds]
print @m.xm1.msky130_fd_pr__nfet_01v8[vth]
print @m.xm1.msky130_fd_pr__nfet_01v8[vdsat]
print @m.xm1.msky130_fd_pr__nfet_01v8[vgs]
print @m.xm1.msky130_fd_pr__nfet_01v8[vds]
print @m.xm1.msky130_fd_pr__nfet_01v8[vbs]
print @m.xm2.msky130_fd_pr__nfet_01v8[id]
print @m.xm2.msky130_fd_pr__nfet_01v8[gm]
print @m.xm2.msky130_fd_pr__nfet_01v8[gds]
print @m.xm2.msky130_fd_pr__nfet_01v8[vth]
print @m.xm2.msky130_fd_pr__nfet_01v8[vdsat]
print @m.xm2.msky130_fd_pr__nfet_01v8[vgs]
print @m.xm2.msky130_fd_pr__nfet_01v8[vds]
print @m.xm2.msky130_fd_pr__nfet_01v8[vbs]
print @m.xm3.msky130_fd_pr__pfet_01v8[id]
print @m.xm3.msky130_fd_pr__pfet_01v8[gm]
print @m.xm3.msky130_fd_pr__pfet_01v8[gds]
print @m.xm3.msky130_fd_pr__pfet_01v8[vth]
print @m.xm3.msky130_fd_pr__pfet_01v8[vdsat]
print @m.xm3.msky130_fd_pr__pfet_01v8[vgs]
print @m.xm3.msky130_fd_pr__pfet_01v8[vds]
print @m.xm3.msky130_fd_pr__pfet_01v8[vbs]
print @m.xm4.msky130_fd_pr__pfet_01v8[id]
print @m.xm4.msky130_fd_pr__pfet_01v8[gm]
print @m.xm4.msky130_fd_pr__pfet_01v8[gds]
print @m.xm4.msky130_fd_pr__pfet_01v8[vth]
print @m.xm4.msky130_fd_pr__pfet_01v8[vdsat]
print @m.xm4.msky130_fd_pr__pfet_01v8[vgs]
print @m.xm4.msky130_fd_pr__pfet_01v8[vds]
print @m.xm4.msky130_fd_pr__pfet_01v8[vbs]
print v(d1)
print v(inp)
print v(tail)
print v(out)
print v(inn)
print v(vdd)
print i(vrail_vdd)
echo OPEND
alter vofs_inn dc = -0.17798495
alter vdc_inp dc = 1.08201595
echo SWP 43
op
echo OPSTART
print @m.xm1.msky130_fd_pr__nfet_01v8[id]
print @m.xm1.msky130_fd_pr__nfet_01v8[gm]
print @m.xm1.msky130_fd_pr__nfet_01v8[gds]
print @m.xm1.msky130_fd_pr__nfet_01v8[vth]
print @m.xm1.msky130_fd_pr__nfet_01v8[vdsat]
print @m.xm1.msky130_fd_pr__nfet_01v8[vgs]
print @m.xm1.msky130_fd_pr__nfet_01v8[vds]
print @m.xm1.msky130_fd_pr__nfet_01v8[vbs]
print @m.xm2.msky130_fd_pr__nfet_01v8[id]
print @m.xm2.msky130_fd_pr__nfet_01v8[gm]
print @m.xm2.msky130_fd_pr__nfet_01v8[gds]
print @m.xm2.msky130_fd_pr__nfet_01v8[vth]
print @m.xm2.msky130_fd_pr__nfet_01v8[vdsat]
print @m.xm2.msky130_fd_pr__nfet_01v8[vgs]
print @m.xm2.msky130_fd_pr__nfet_01v8[vds]
print @m.xm2.msky130_fd_pr__nfet_01v8[vbs]
print @m.xm3.msky130_fd_pr__pfet_01v8[id]
print @m.xm3.msky130_fd_pr__pfet_01v8[gm]
print @m.xm3.msky130_fd_pr__pfet_01v8[gds]
print @m.xm3.msky130_fd_pr__pfet_01v8[vth]
print @m.xm3.msky130_fd_pr__pfet_01v8[vdsat]
print @m.xm3.msky130_fd_pr__pfet_01v8[vgs]
print @m.xm3.msky130_fd_pr__pfet_01v8[vds]
print @m.xm3.msky130_fd_pr__pfet_01v8[vbs]
print @m.xm4.msky130_fd_pr__pfet_01v8[id]
print @m.xm4.msky130_fd_pr__pfet_01v8[gm]
print @m.xm4.msky130_fd_pr__pfet_01v8[gds]
print @m.xm4.msky130_fd_pr__pfet_01v8[vth]
print @m.xm4.msky130_fd_pr__pfet_01v8[vdsat]
print @m.xm4.msky130_fd_pr__pfet_01v8[vgs]
print @m.xm4.msky130_fd_pr__pfet_01v8[vds]
print @m.xm4.msky130_fd_pr__pfet_01v8[vbs]
print v(d1)
print v(inp)
print v(tail)
print v(out)
print v(inn)
print v(vdd)
print i(vrail_vdd)
echo OPEND
alter vofs_inn dc = -0.203699235714
alter vdc_inp dc = 1.10773023571
echo SWP 44
op
echo OPSTART
print @m.xm1.msky130_fd_pr__nfet_01v8[id]
print @m.xm1.msky130_fd_pr__nfet_01v8[gm]
print @m.xm1.msky130_fd_pr__nfet_01v8[gds]
print @m.xm1.msky130_fd_pr__nfet_01v8[vth]
print @m.xm1.msky130_fd_pr__nfet_01v8[vdsat]
print @m.xm1.msky130_fd_pr__nfet_01v8[vgs]
print @m.xm1.msky130_fd_pr__nfet_01v8[vds]
print @m.xm1.msky130_fd_pr__nfet_01v8[vbs]
print @m.xm2.msky130_fd_pr__nfet_01v8[id]
print @m.xm2.msky130_fd_pr__nfet_01v8[gm]
print @m.xm2.msky130_fd_pr__nfet_01v8[gds]
print @m.xm2.msky130_fd_pr__nfet_01v8[vth]
print @m.xm2.msky130_fd_pr__nfet_01v8[vdsat]
print @m.xm2.msky130_fd_pr__nfet_01v8[vgs]
print @m.xm2.msky130_fd_pr__nfet_01v8[vds]
print @m.xm2.msky130_fd_pr__nfet_01v8[vbs]
print @m.xm3.msky130_fd_pr__pfet_01v8[id]
print @m.xm3.msky130_fd_pr__pfet_01v8[gm]
print @m.xm3.msky130_fd_pr__pfet_01v8[gds]
print @m.xm3.msky130_fd_pr__pfet_01v8[vth]
print @m.xm3.msky130_fd_pr__pfet_01v8[vdsat]
print @m.xm3.msky130_fd_pr__pfet_01v8[vgs]
print @m.xm3.msky130_fd_pr__pfet_01v8[vds]
print @m.xm3.msky130_fd_pr__pfet_01v8[vbs]
print @m.xm4.msky130_fd_pr__pfet_01v8[id]
print @m.xm4.msky130_fd_pr__pfet_01v8[gm]
print @m.xm4.msky130_fd_pr__pfet_01v8[gds]
print @m.xm4.msky130_fd_pr__pfet_01v8[vth]
print @m.xm4.msky130_fd_pr__pfet_01v8[vdsat]
print @m.xm4.msky130_fd_pr__pfet_01v8[vgs]
print @m.xm4.msky130_fd_pr__pfet_01v8[vds]
print @m.xm4.msky130_fd_pr__pfet_01v8[vbs]
print v(d1)
print v(inp)
print v(tail)
print v(out)
print v(inn)
print v(vdd)
print i(vrail_vdd)
echo OPEND
alter vofs_inn dc = -0.229413521429
alter vdc_inp dc = 1.13344452143
echo SWP 45
op
echo OPSTART
print @m.xm1.msky130_fd_pr__nfet_01v8[id]
print @m.xm1.msky130_fd_pr__nfet_01v8[gm]
print @m.xm1.msky130_fd_pr__nfet_01v8[gds]
print @m.xm1.msky130_fd_pr__nfet_01v8[vth]
print @m.xm1.msky130_fd_pr__nfet_01v8[vdsat]
print @m.xm1.msky130_fd_pr__nfet_01v8[vgs]
print @m.xm1.msky130_fd_pr__nfet_01v8[vds]
print @m.xm1.msky130_fd_pr__nfet_01v8[vbs]
print @m.xm2.msky130_fd_pr__nfet_01v8[id]
print @m.xm2.msky130_fd_pr__nfet_01v8[gm]
print @m.xm2.msky130_fd_pr__nfet_01v8[gds]
print @m.xm2.msky130_fd_pr__nfet_01v8[vth]
print @m.xm2.msky130_fd_pr__nfet_01v8[vdsat]
print @m.xm2.msky130_fd_pr__nfet_01v8[vgs]
print @m.xm2.msky130_fd_pr__nfet_01v8[vds]
print @m.xm2.msky130_fd_pr__nfet_01v8[vbs]
print @m.xm3.msky130_fd_pr__pfet_01v8[id]
print @m.xm3.msky130_fd_pr__pfet_01v8[gm]
print @m.xm3.msky130_fd_pr__pfet_01v8[gds]
print @m.xm3.msky130_fd_pr__pfet_01v8[vth]
print @m.xm3.msky130_fd_pr__pfet_01v8[vdsat]
print @m.xm3.msky130_fd_pr__pfet_01v8[vgs]
print @m.xm3.msky130_fd_pr__pfet_01v8[vds]
print @m.xm3.msky130_fd_pr__pfet_01v8[vbs]
print @m.xm4.msky130_fd_pr__pfet_01v8[id]
print @m.xm4.msky130_fd_pr__pfet_01v8[gm]
print @m.xm4.msky130_fd_pr__pfet_01v8[gds]
print @m.xm4.msky130_fd_pr__pfet_01v8[vth]
print @m.xm4.msky130_fd_pr__pfet_01v8[vdsat]
print @m.xm4.msky130_fd_pr__pfet_01v8[vgs]
print @m.xm4.msky130_fd_pr__pfet_01v8[vds]
print @m.xm4.msky130_fd_pr__pfet_01v8[vbs]
print v(d1)
print v(inp)
print v(tail)
print v(out)
print v(inn)
print v(vdd)
print i(vrail_vdd)
echo OPEND
alter vofs_inn dc = -0.255127807143
alter vdc_inp dc = 1.15915880714
echo SWP 46
op
echo OPSTART
print @m.xm1.msky130_fd_pr__nfet_01v8[id]
print @m.xm1.msky130_fd_pr__nfet_01v8[gm]
print @m.xm1.msky130_fd_pr__nfet_01v8[gds]
print @m.xm1.msky130_fd_pr__nfet_01v8[vth]
print @m.xm1.msky130_fd_pr__nfet_01v8[vdsat]
print @m.xm1.msky130_fd_pr__nfet_01v8[vgs]
print @m.xm1.msky130_fd_pr__nfet_01v8[vds]
print @m.xm1.msky130_fd_pr__nfet_01v8[vbs]
print @m.xm2.msky130_fd_pr__nfet_01v8[id]
print @m.xm2.msky130_fd_pr__nfet_01v8[gm]
print @m.xm2.msky130_fd_pr__nfet_01v8[gds]
print @m.xm2.msky130_fd_pr__nfet_01v8[vth]
print @m.xm2.msky130_fd_pr__nfet_01v8[vdsat]
print @m.xm2.msky130_fd_pr__nfet_01v8[vgs]
print @m.xm2.msky130_fd_pr__nfet_01v8[vds]
print @m.xm2.msky130_fd_pr__nfet_01v8[vbs]
print @m.xm3.msky130_fd_pr__pfet_01v8[id]
print @m.xm3.msky130_fd_pr__pfet_01v8[gm]
print @m.xm3.msky130_fd_pr__pfet_01v8[gds]
print @m.xm3.msky130_fd_pr__pfet_01v8[vth]
print @m.xm3.msky130_fd_pr__pfet_01v8[vdsat]
print @m.xm3.msky130_fd_pr__pfet_01v8[vgs]
print @m.xm3.msky130_fd_pr__pfet_01v8[vds]
print @m.xm3.msky130_fd_pr__pfet_01v8[vbs]
print @m.xm4.msky130_fd_pr__pfet_01v8[id]
print @m.xm4.msky130_fd_pr__pfet_01v8[gm]
print @m.xm4.msky130_fd_pr__pfet_01v8[gds]
print @m.xm4.msky130_fd_pr__pfet_01v8[vth]
print @m.xm4.msky130_fd_pr__pfet_01v8[vdsat]
print @m.xm4.msky130_fd_pr__pfet_01v8[vgs]
print @m.xm4.msky130_fd_pr__pfet_01v8[vds]
print @m.xm4.msky130_fd_pr__pfet_01v8[vbs]
print v(d1)
print v(inp)
print v(tail)
print v(out)
print v(inn)
print v(vdd)
print i(vrail_vdd)
echo OPEND
alter vofs_inn dc = -0.280842092857
alter vdc_inp dc = 1.18487309286
echo SWP 47
op
echo OPSTART
print @m.xm1.msky130_fd_pr__nfet_01v8[id]
print @m.xm1.msky130_fd_pr__nfet_01v8[gm]
print @m.xm1.msky130_fd_pr__nfet_01v8[gds]
print @m.xm1.msky130_fd_pr__nfet_01v8[vth]
print @m.xm1.msky130_fd_pr__nfet_01v8[vdsat]
print @m.xm1.msky130_fd_pr__nfet_01v8[vgs]
print @m.xm1.msky130_fd_pr__nfet_01v8[vds]
print @m.xm1.msky130_fd_pr__nfet_01v8[vbs]
print @m.xm2.msky130_fd_pr__nfet_01v8[id]
print @m.xm2.msky130_fd_pr__nfet_01v8[gm]
print @m.xm2.msky130_fd_pr__nfet_01v8[gds]
print @m.xm2.msky130_fd_pr__nfet_01v8[vth]
print @m.xm2.msky130_fd_pr__nfet_01v8[vdsat]
print @m.xm2.msky130_fd_pr__nfet_01v8[vgs]
print @m.xm2.msky130_fd_pr__nfet_01v8[vds]
print @m.xm2.msky130_fd_pr__nfet_01v8[vbs]
print @m.xm3.msky130_fd_pr__pfet_01v8[id]
print @m.xm3.msky130_fd_pr__pfet_01v8[gm]
print @m.xm3.msky130_fd_pr__pfet_01v8[gds]
print @m.xm3.msky130_fd_pr__pfet_01v8[vth]
print @m.xm3.msky130_fd_pr__pfet_01v8[vdsat]
print @m.xm3.msky130_fd_pr__pfet_01v8[vgs]
print @m.xm3.msky130_fd_pr__pfet_01v8[vds]
print @m.xm3.msky130_fd_pr__pfet_01v8[vbs]
print @m.xm4.msky130_fd_pr__pfet_01v8[id]
print @m.xm4.msky130_fd_pr__pfet_01v8[gm]
print @m.xm4.msky130_fd_pr__pfet_01v8[gds]
print @m.xm4.msky130_fd_pr__pfet_01v8[vth]
print @m.xm4.msky130_fd_pr__pfet_01v8[vdsat]
print @m.xm4.msky130_fd_pr__pfet_01v8[vgs]
print @m.xm4.msky130_fd_pr__pfet_01v8[vds]
print @m.xm4.msky130_fd_pr__pfet_01v8[vbs]
print v(d1)
print v(inp)
print v(tail)
print v(out)
print v(inn)
print v(vdd)
print i(vrail_vdd)
echo OPEND
alter vofs_inn dc = -0.306556378571
alter vdc_inp dc = 1.21058737857
echo SWP 48
op
echo OPSTART
print @m.xm1.msky130_fd_pr__nfet_01v8[id]
print @m.xm1.msky130_fd_pr__nfet_01v8[gm]
print @m.xm1.msky130_fd_pr__nfet_01v8[gds]
print @m.xm1.msky130_fd_pr__nfet_01v8[vth]
print @m.xm1.msky130_fd_pr__nfet_01v8[vdsat]
print @m.xm1.msky130_fd_pr__nfet_01v8[vgs]
print @m.xm1.msky130_fd_pr__nfet_01v8[vds]
print @m.xm1.msky130_fd_pr__nfet_01v8[vbs]
print @m.xm2.msky130_fd_pr__nfet_01v8[id]
print @m.xm2.msky130_fd_pr__nfet_01v8[gm]
print @m.xm2.msky130_fd_pr__nfet_01v8[gds]
print @m.xm2.msky130_fd_pr__nfet_01v8[vth]
print @m.xm2.msky130_fd_pr__nfet_01v8[vdsat]
print @m.xm2.msky130_fd_pr__nfet_01v8[vgs]
print @m.xm2.msky130_fd_pr__nfet_01v8[vds]
print @m.xm2.msky130_fd_pr__nfet_01v8[vbs]
print @m.xm3.msky130_fd_pr__pfet_01v8[id]
print @m.xm3.msky130_fd_pr__pfet_01v8[gm]
print @m.xm3.msky130_fd_pr__pfet_01v8[gds]
print @m.xm3.msky130_fd_pr__pfet_01v8[vth]
print @m.xm3.msky130_fd_pr__pfet_01v8[vdsat]
print @m.xm3.msky130_fd_pr__pfet_01v8[vgs]
print @m.xm3.msky130_fd_pr__pfet_01v8[vds]
print @m.xm3.msky130_fd_pr__pfet_01v8[vbs]
print @m.xm4.msky130_fd_pr__pfet_01v8[id]
print @m.xm4.msky130_fd_pr__pfet_01v8[gm]
print @m.xm4.msky130_fd_pr__pfet_01v8[gds]
print @m.xm4.msky130_fd_pr__pfet_01v8[vth]
print @m.xm4.msky130_fd_pr__pfet_01v8[vdsat]
print @m.xm4.msky130_fd_pr__pfet_01v8[vgs]
print @m.xm4.msky130_fd_pr__pfet_01v8[vds]
print @m.xm4.msky130_fd_pr__pfet_01v8[vbs]
print v(d1)
print v(inp)
print v(tail)
print v(out)
print v(inn)
print v(vdd)
print i(vrail_vdd)
echo OPEND
alter vofs_inn dc = -0.332270664286
alter vdc_inp dc = 1.23630166429
echo SWP 49
op
echo OPSTART
print @m.xm1.msky130_fd_pr__nfet_01v8[id]
print @m.xm1.msky130_fd_pr__nfet_01v8[gm]
print @m.xm1.msky130_fd_pr__nfet_01v8[gds]
print @m.xm1.msky130_fd_pr__nfet_01v8[vth]
print @m.xm1.msky130_fd_pr__nfet_01v8[vdsat]
print @m.xm1.msky130_fd_pr__nfet_01v8[vgs]
print @m.xm1.msky130_fd_pr__nfet_01v8[vds]
print @m.xm1.msky130_fd_pr__nfet_01v8[vbs]
print @m.xm2.msky130_fd_pr__nfet_01v8[id]
print @m.xm2.msky130_fd_pr__nfet_01v8[gm]
print @m.xm2.msky130_fd_pr__nfet_01v8[gds]
print @m.xm2.msky130_fd_pr__nfet_01v8[vth]
print @m.xm2.msky130_fd_pr__nfet_01v8[vdsat]
print @m.xm2.msky130_fd_pr__nfet_01v8[vgs]
print @m.xm2.msky130_fd_pr__nfet_01v8[vds]
print @m.xm2.msky130_fd_pr__nfet_01v8[vbs]
print @m.xm3.msky130_fd_pr__pfet_01v8[id]
print @m.xm3.msky130_fd_pr__pfet_01v8[gm]
print @m.xm3.msky130_fd_pr__pfet_01v8[gds]
print @m.xm3.msky130_fd_pr__pfet_01v8[vth]
print @m.xm3.msky130_fd_pr__pfet_01v8[vdsat]
print @m.xm3.msky130_fd_pr__pfet_01v8[vgs]
print @m.xm3.msky130_fd_pr__pfet_01v8[vds]
print @m.xm3.msky130_fd_pr__pfet_01v8[vbs]
print @m.xm4.msky130_fd_pr__pfet_01v8[id]
print @m.xm4.msky130_fd_pr__pfet_01v8[gm]
print @m.xm4.msky130_fd_pr__pfet_01v8[gds]
print @m.xm4.msky130_fd_pr__pfet_01v8[vth]
print @m.xm4.msky130_fd_pr__pfet_01v8[vdsat]
print @m.xm4.msky130_fd_pr__pfet_01v8[vgs]
print @m.xm4.msky130_fd_pr__pfet_01v8[vds]
print @m.xm4.msky130_fd_pr__pfet_01v8[vbs]
print v(d1)
print v(inp)
print v(tail)
print v(out)
print v(inn)
print v(vdd)
print i(vrail_vdd)
echo OPEND
alter vofs_inn dc = -0.35798495
alter vdc_inp dc = 1.26201595
echo SWP 50
op
echo OPSTART
print @m.xm1.msky130_fd_pr__nfet_01v8[id]
print @m.xm1.msky130_fd_pr__nfet_01v8[gm]
print @m.xm1.msky130_fd_pr__nfet_01v8[gds]
print @m.xm1.msky130_fd_pr__nfet_01v8[vth]
print @m.xm1.msky130_fd_pr__nfet_01v8[vdsat]
print @m.xm1.msky130_fd_pr__nfet_01v8[vgs]
print @m.xm1.msky130_fd_pr__nfet_01v8[vds]
print @m.xm1.msky130_fd_pr__nfet_01v8[vbs]
print @m.xm2.msky130_fd_pr__nfet_01v8[id]
print @m.xm2.msky130_fd_pr__nfet_01v8[gm]
print @m.xm2.msky130_fd_pr__nfet_01v8[gds]
print @m.xm2.msky130_fd_pr__nfet_01v8[vth]
print @m.xm2.msky130_fd_pr__nfet_01v8[vdsat]
print @m.xm2.msky130_fd_pr__nfet_01v8[vgs]
print @m.xm2.msky130_fd_pr__nfet_01v8[vds]
print @m.xm2.msky130_fd_pr__nfet_01v8[vbs]
print @m.xm3.msky130_fd_pr__pfet_01v8[id]
print @m.xm3.msky130_fd_pr__pfet_01v8[gm]
print @m.xm3.msky130_fd_pr__pfet_01v8[gds]
print @m.xm3.msky130_fd_pr__pfet_01v8[vth]
print @m.xm3.msky130_fd_pr__pfet_01v8[vdsat]
print @m.xm3.msky130_fd_pr__pfet_01v8[vgs]
print @m.xm3.msky130_fd_pr__pfet_01v8[vds]
print @m.xm3.msky130_fd_pr__pfet_01v8[vbs]
print @m.xm4.msky130_fd_pr__pfet_01v8[id]
print @m.xm4.msky130_fd_pr__pfet_01v8[gm]
print @m.xm4.msky130_fd_pr__pfet_01v8[gds]
print @m.xm4.msky130_fd_pr__pfet_01v8[vth]
print @m.xm4.msky130_fd_pr__pfet_01v8[vdsat]
print @m.xm4.msky130_fd_pr__pfet_01v8[vgs]
print @m.xm4.msky130_fd_pr__pfet_01v8[vds]
print @m.xm4.msky130_fd_pr__pfet_01v8[vbs]
print v(d1)
print v(inp)
print v(tail)
print v(out)
print v(inn)
print v(vdd)
print i(vrail_vdd)
echo OPEND
alter vofs_inn dc = -0.383699235714
alter vdc_inp dc = 1.28773023571
echo SWP 51
op
echo OPSTART
print @m.xm1.msky130_fd_pr__nfet_01v8[id]
print @m.xm1.msky130_fd_pr__nfet_01v8[gm]
print @m.xm1.msky130_fd_pr__nfet_01v8[gds]
print @m.xm1.msky130_fd_pr__nfet_01v8[vth]
print @m.xm1.msky130_fd_pr__nfet_01v8[vdsat]
print @m.xm1.msky130_fd_pr__nfet_01v8[vgs]
print @m.xm1.msky130_fd_pr__nfet_01v8[vds]
print @m.xm1.msky130_fd_pr__nfet_01v8[vbs]
print @m.xm2.msky130_fd_pr__nfet_01v8[id]
print @m.xm2.msky130_fd_pr__nfet_01v8[gm]
print @m.xm2.msky130_fd_pr__nfet_01v8[gds]
print @m.xm2.msky130_fd_pr__nfet_01v8[vth]
print @m.xm2.msky130_fd_pr__nfet_01v8[vdsat]
print @m.xm2.msky130_fd_pr__nfet_01v8[vgs]
print @m.xm2.msky130_fd_pr__nfet_01v8[vds]
print @m.xm2.msky130_fd_pr__nfet_01v8[vbs]
print @m.xm3.msky130_fd_pr__pfet_01v8[id]
print @m.xm3.msky130_fd_pr__pfet_01v8[gm]
print @m.xm3.msky130_fd_pr__pfet_01v8[gds]
print @m.xm3.msky130_fd_pr__pfet_01v8[vth]
print @m.xm3.msky130_fd_pr__pfet_01v8[vdsat]
print @m.xm3.msky130_fd_pr__pfet_01v8[vgs]
print @m.xm3.msky130_fd_pr__pfet_01v8[vds]
print @m.xm3.msky130_fd_pr__pfet_01v8[vbs]
print @m.xm4.msky130_fd_pr__pfet_01v8[id]
print @m.xm4.msky130_fd_pr__pfet_01v8[gm]
print @m.xm4.msky130_fd_pr__pfet_01v8[gds]
print @m.xm4.msky130_fd_pr__pfet_01v8[vth]
print @m.xm4.msky130_fd_pr__pfet_01v8[vdsat]
print @m.xm4.msky130_fd_pr__pfet_01v8[vgs]
print @m.xm4.msky130_fd_pr__pfet_01v8[vds]
print @m.xm4.msky130_fd_pr__pfet_01v8[vbs]
print v(d1)
print v(inp)
print v(tail)
print v(out)
print v(inn)
print v(vdd)
print i(vrail_vdd)
echo OPEND
alter vofs_inn dc = -0.409413521429
alter vdc_inp dc = 1.31344452143
echo SWP 52
op
echo OPSTART
print @m.xm1.msky130_fd_pr__nfet_01v8[id]
print @m.xm1.msky130_fd_pr__nfet_01v8[gm]
print @m.xm1.msky130_fd_pr__nfet_01v8[gds]
print @m.xm1.msky130_fd_pr__nfet_01v8[vth]
print @m.xm1.msky130_fd_pr__nfet_01v8[vdsat]
print @m.xm1.msky130_fd_pr__nfet_01v8[vgs]
print @m.xm1.msky130_fd_pr__nfet_01v8[vds]
print @m.xm1.msky130_fd_pr__nfet_01v8[vbs]
print @m.xm2.msky130_fd_pr__nfet_01v8[id]
print @m.xm2.msky130_fd_pr__nfet_01v8[gm]
print @m.xm2.msky130_fd_pr__nfet_01v8[gds]
print @m.xm2.msky130_fd_pr__nfet_01v8[vth]
print @m.xm2.msky130_fd_pr__nfet_01v8[vdsat]
print @m.xm2.msky130_fd_pr__nfet_01v8[vgs]
print @m.xm2.msky130_fd_pr__nfet_01v8[vds]
print @m.xm2.msky130_fd_pr__nfet_01v8[vbs]
print @m.xm3.msky130_fd_pr__pfet_01v8[id]
print @m.xm3.msky130_fd_pr__pfet_01v8[gm]
print @m.xm3.msky130_fd_pr__pfet_01v8[gds]
print @m.xm3.msky130_fd_pr__pfet_01v8[vth]
print @m.xm3.msky130_fd_pr__pfet_01v8[vdsat]
print @m.xm3.msky130_fd_pr__pfet_01v8[vgs]
print @m.xm3.msky130_fd_pr__pfet_01v8[vds]
print @m.xm3.msky130_fd_pr__pfet_01v8[vbs]
print @m.xm4.msky130_fd_pr__pfet_01v8[id]
print @m.xm4.msky130_fd_pr__pfet_01v8[gm]
print @m.xm4.msky130_fd_pr__pfet_01v8[gds]
print @m.xm4.msky130_fd_pr__pfet_01v8[vth]
print @m.xm4.msky130_fd_pr__pfet_01v8[vdsat]
print @m.xm4.msky130_fd_pr__pfet_01v8[vgs]
print @m.xm4.msky130_fd_pr__pfet_01v8[vds]
print @m.xm4.msky130_fd_pr__pfet_01v8[vbs]
print v(d1)
print v(inp)
print v(tail)
print v(out)
print v(inn)
print v(vdd)
print i(vrail_vdd)
echo OPEND
alter vofs_inn dc = -0.435127807143
alter vdc_inp dc = 1.33915880714
echo SWP 53
op
echo OPSTART
print @m.xm1.msky130_fd_pr__nfet_01v8[id]
print @m.xm1.msky130_fd_pr__nfet_01v8[gm]
print @m.xm1.msky130_fd_pr__nfet_01v8[gds]
print @m.xm1.msky130_fd_pr__nfet_01v8[vth]
print @m.xm1.msky130_fd_pr__nfet_01v8[vdsat]
print @m.xm1.msky130_fd_pr__nfet_01v8[vgs]
print @m.xm1.msky130_fd_pr__nfet_01v8[vds]
print @m.xm1.msky130_fd_pr__nfet_01v8[vbs]
print @m.xm2.msky130_fd_pr__nfet_01v8[id]
print @m.xm2.msky130_fd_pr__nfet_01v8[gm]
print @m.xm2.msky130_fd_pr__nfet_01v8[gds]
print @m.xm2.msky130_fd_pr__nfet_01v8[vth]
print @m.xm2.msky130_fd_pr__nfet_01v8[vdsat]
print @m.xm2.msky130_fd_pr__nfet_01v8[vgs]
print @m.xm2.msky130_fd_pr__nfet_01v8[vds]
print @m.xm2.msky130_fd_pr__nfet_01v8[vbs]
print @m.xm3.msky130_fd_pr__pfet_01v8[id]
print @m.xm3.msky130_fd_pr__pfet_01v8[gm]
print @m.xm3.msky130_fd_pr__pfet_01v8[gds]
print @m.xm3.msky130_fd_pr__pfet_01v8[vth]
print @m.xm3.msky130_fd_pr__pfet_01v8[vdsat]
print @m.xm3.msky130_fd_pr__pfet_01v8[vgs]
print @m.xm3.msky130_fd_pr__pfet_01v8[vds]
print @m.xm3.msky130_fd_pr__pfet_01v8[vbs]
print @m.xm4.msky130_fd_pr__pfet_01v8[id]
print @m.xm4.msky130_fd_pr__pfet_01v8[gm]
print @m.xm4.msky130_fd_pr__pfet_01v8[gds]
print @m.xm4.msky130_fd_pr__pfet_01v8[vth]
print @m.xm4.msky130_fd_pr__pfet_01v8[vdsat]
print @m.xm4.msky130_fd_pr__pfet_01v8[vgs]
print @m.xm4.msky130_fd_pr__pfet_01v8[vds]
print @m.xm4.msky130_fd_pr__pfet_01v8[vbs]
print v(d1)
print v(inp)
print v(tail)
print v(out)
print v(inn)
print v(vdd)
print i(vrail_vdd)
echo OPEND
alter vofs_inn dc = -0.460842092857
alter vdc_inp dc = 1.36487309286
echo SWP 54
op
echo OPSTART
print @m.xm1.msky130_fd_pr__nfet_01v8[id]
print @m.xm1.msky130_fd_pr__nfet_01v8[gm]
print @m.xm1.msky130_fd_pr__nfet_01v8[gds]
print @m.xm1.msky130_fd_pr__nfet_01v8[vth]
print @m.xm1.msky130_fd_pr__nfet_01v8[vdsat]
print @m.xm1.msky130_fd_pr__nfet_01v8[vgs]
print @m.xm1.msky130_fd_pr__nfet_01v8[vds]
print @m.xm1.msky130_fd_pr__nfet_01v8[vbs]
print @m.xm2.msky130_fd_pr__nfet_01v8[id]
print @m.xm2.msky130_fd_pr__nfet_01v8[gm]
print @m.xm2.msky130_fd_pr__nfet_01v8[gds]
print @m.xm2.msky130_fd_pr__nfet_01v8[vth]
print @m.xm2.msky130_fd_pr__nfet_01v8[vdsat]
print @m.xm2.msky130_fd_pr__nfet_01v8[vgs]
print @m.xm2.msky130_fd_pr__nfet_01v8[vds]
print @m.xm2.msky130_fd_pr__nfet_01v8[vbs]
print @m.xm3.msky130_fd_pr__pfet_01v8[id]
print @m.xm3.msky130_fd_pr__pfet_01v8[gm]
print @m.xm3.msky130_fd_pr__pfet_01v8[gds]
print @m.xm3.msky130_fd_pr__pfet_01v8[vth]
print @m.xm3.msky130_fd_pr__pfet_01v8[vdsat]
print @m.xm3.msky130_fd_pr__pfet_01v8[vgs]
print @m.xm3.msky130_fd_pr__pfet_01v8[vds]
print @m.xm3.msky130_fd_pr__pfet_01v8[vbs]
print @m.xm4.msky130_fd_pr__pfet_01v8[id]
print @m.xm4.msky130_fd_pr__pfet_01v8[gm]
print @m.xm4.msky130_fd_pr__pfet_01v8[gds]
print @m.xm4.msky130_fd_pr__pfet_01v8[vth]
print @m.xm4.msky130_fd_pr__pfet_01v8[vdsat]
print @m.xm4.msky130_fd_pr__pfet_01v8[vgs]
print @m.xm4.msky130_fd_pr__pfet_01v8[vds]
print @m.xm4.msky130_fd_pr__pfet_01v8[vbs]
print v(d1)
print v(inp)
print v(tail)
print v(out)
print v(inn)
print v(vdd)
print i(vrail_vdd)
echo OPEND
alter vofs_inn dc = -0.486556378571
alter vdc_inp dc = 1.39058737857
echo SWP 55
op
echo OPSTART
print @m.xm1.msky130_fd_pr__nfet_01v8[id]
print @m.xm1.msky130_fd_pr__nfet_01v8[gm]
print @m.xm1.msky130_fd_pr__nfet_01v8[gds]
print @m.xm1.msky130_fd_pr__nfet_01v8[vth]
print @m.xm1.msky130_fd_pr__nfet_01v8[vdsat]
print @m.xm1.msky130_fd_pr__nfet_01v8[vgs]
print @m.xm1.msky130_fd_pr__nfet_01v8[vds]
print @m.xm1.msky130_fd_pr__nfet_01v8[vbs]
print @m.xm2.msky130_fd_pr__nfet_01v8[id]
print @m.xm2.msky130_fd_pr__nfet_01v8[gm]
print @m.xm2.msky130_fd_pr__nfet_01v8[gds]
print @m.xm2.msky130_fd_pr__nfet_01v8[vth]
print @m.xm2.msky130_fd_pr__nfet_01v8[vdsat]
print @m.xm2.msky130_fd_pr__nfet_01v8[vgs]
print @m.xm2.msky130_fd_pr__nfet_01v8[vds]
print @m.xm2.msky130_fd_pr__nfet_01v8[vbs]
print @m.xm3.msky130_fd_pr__pfet_01v8[id]
print @m.xm3.msky130_fd_pr__pfet_01v8[gm]
print @m.xm3.msky130_fd_pr__pfet_01v8[gds]
print @m.xm3.msky130_fd_pr__pfet_01v8[vth]
print @m.xm3.msky130_fd_pr__pfet_01v8[vdsat]
print @m.xm3.msky130_fd_pr__pfet_01v8[vgs]
print @m.xm3.msky130_fd_pr__pfet_01v8[vds]
print @m.xm3.msky130_fd_pr__pfet_01v8[vbs]
print @m.xm4.msky130_fd_pr__pfet_01v8[id]
print @m.xm4.msky130_fd_pr__pfet_01v8[gm]
print @m.xm4.msky130_fd_pr__pfet_01v8[gds]
print @m.xm4.msky130_fd_pr__pfet_01v8[vth]
print @m.xm4.msky130_fd_pr__pfet_01v8[vdsat]
print @m.xm4.msky130_fd_pr__pfet_01v8[vgs]
print @m.xm4.msky130_fd_pr__pfet_01v8[vds]
print @m.xm4.msky130_fd_pr__pfet_01v8[vbs]
print v(d1)
print v(inp)
print v(tail)
print v(out)
print v(inn)
print v(vdd)
print i(vrail_vdd)
echo OPEND
alter vofs_inn dc = -0.512270664286
alter vdc_inp dc = 1.41630166429
echo SWP 56
op
echo OPSTART
print @m.xm1.msky130_fd_pr__nfet_01v8[id]
print @m.xm1.msky130_fd_pr__nfet_01v8[gm]
print @m.xm1.msky130_fd_pr__nfet_01v8[gds]
print @m.xm1.msky130_fd_pr__nfet_01v8[vth]
print @m.xm1.msky130_fd_pr__nfet_01v8[vdsat]
print @m.xm1.msky130_fd_pr__nfet_01v8[vgs]
print @m.xm1.msky130_fd_pr__nfet_01v8[vds]
print @m.xm1.msky130_fd_pr__nfet_01v8[vbs]
print @m.xm2.msky130_fd_pr__nfet_01v8[id]
print @m.xm2.msky130_fd_pr__nfet_01v8[gm]
print @m.xm2.msky130_fd_pr__nfet_01v8[gds]
print @m.xm2.msky130_fd_pr__nfet_01v8[vth]
print @m.xm2.msky130_fd_pr__nfet_01v8[vdsat]
print @m.xm2.msky130_fd_pr__nfet_01v8[vgs]
print @m.xm2.msky130_fd_pr__nfet_01v8[vds]
print @m.xm2.msky130_fd_pr__nfet_01v8[vbs]
print @m.xm3.msky130_fd_pr__pfet_01v8[id]
print @m.xm3.msky130_fd_pr__pfet_01v8[gm]
print @m.xm3.msky130_fd_pr__pfet_01v8[gds]
print @m.xm3.msky130_fd_pr__pfet_01v8[vth]
print @m.xm3.msky130_fd_pr__pfet_01v8[vdsat]
print @m.xm3.msky130_fd_pr__pfet_01v8[vgs]
print @m.xm3.msky130_fd_pr__pfet_01v8[vds]
print @m.xm3.msky130_fd_pr__pfet_01v8[vbs]
print @m.xm4.msky130_fd_pr__pfet_01v8[id]
print @m.xm4.msky130_fd_pr__pfet_01v8[gm]
print @m.xm4.msky130_fd_pr__pfet_01v8[gds]
print @m.xm4.msky130_fd_pr__pfet_01v8[vth]
print @m.xm4.msky130_fd_pr__pfet_01v8[vdsat]
print @m.xm4.msky130_fd_pr__pfet_01v8[vgs]
print @m.xm4.msky130_fd_pr__pfet_01v8[vds]
print @m.xm4.msky130_fd_pr__pfet_01v8[vbs]
print v(d1)
print v(inp)
print v(tail)
print v(out)
print v(inn)
print v(vdd)
print i(vrail_vdd)
echo OPEND
alter vofs_inn dc = -0.53798495
alter vdc_inp dc = 1.44201595
echo SWP 57
op
echo OPSTART
print @m.xm1.msky130_fd_pr__nfet_01v8[id]
print @m.xm1.msky130_fd_pr__nfet_01v8[gm]
print @m.xm1.msky130_fd_pr__nfet_01v8[gds]
print @m.xm1.msky130_fd_pr__nfet_01v8[vth]
print @m.xm1.msky130_fd_pr__nfet_01v8[vdsat]
print @m.xm1.msky130_fd_pr__nfet_01v8[vgs]
print @m.xm1.msky130_fd_pr__nfet_01v8[vds]
print @m.xm1.msky130_fd_pr__nfet_01v8[vbs]
print @m.xm2.msky130_fd_pr__nfet_01v8[id]
print @m.xm2.msky130_fd_pr__nfet_01v8[gm]
print @m.xm2.msky130_fd_pr__nfet_01v8[gds]
print @m.xm2.msky130_fd_pr__nfet_01v8[vth]
print @m.xm2.msky130_fd_pr__nfet_01v8[vdsat]
print @m.xm2.msky130_fd_pr__nfet_01v8[vgs]
print @m.xm2.msky130_fd_pr__nfet_01v8[vds]
print @m.xm2.msky130_fd_pr__nfet_01v8[vbs]
print @m.xm3.msky130_fd_pr__pfet_01v8[id]
print @m.xm3.msky130_fd_pr__pfet_01v8[gm]
print @m.xm3.msky130_fd_pr__pfet_01v8[gds]
print @m.xm3.msky130_fd_pr__pfet_01v8[vth]
print @m.xm3.msky130_fd_pr__pfet_01v8[vdsat]
print @m.xm3.msky130_fd_pr__pfet_01v8[vgs]
print @m.xm3.msky130_fd_pr__pfet_01v8[vds]
print @m.xm3.msky130_fd_pr__pfet_01v8[vbs]
print @m.xm4.msky130_fd_pr__pfet_01v8[id]
print @m.xm4.msky130_fd_pr__pfet_01v8[gm]
print @m.xm4.msky130_fd_pr__pfet_01v8[gds]
print @m.xm4.msky130_fd_pr__pfet_01v8[vth]
print @m.xm4.msky130_fd_pr__pfet_01v8[vdsat]
print @m.xm4.msky130_fd_pr__pfet_01v8[vgs]
print @m.xm4.msky130_fd_pr__pfet_01v8[vds]
print @m.xm4.msky130_fd_pr__pfet_01v8[vbs]
print v(d1)
print v(inp)
print v(tail)
print v(out)
print v(inn)
print v(vdd)
print i(vrail_vdd)
echo OPEND
alter vofs_inn dc = -0.563699235714
alter vdc_inp dc = 1.46773023571
echo SWP 58
op
echo OPSTART
print @m.xm1.msky130_fd_pr__nfet_01v8[id]
print @m.xm1.msky130_fd_pr__nfet_01v8[gm]
print @m.xm1.msky130_fd_pr__nfet_01v8[gds]
print @m.xm1.msky130_fd_pr__nfet_01v8[vth]
print @m.xm1.msky130_fd_pr__nfet_01v8[vdsat]
print @m.xm1.msky130_fd_pr__nfet_01v8[vgs]
print @m.xm1.msky130_fd_pr__nfet_01v8[vds]
print @m.xm1.msky130_fd_pr__nfet_01v8[vbs]
print @m.xm2.msky130_fd_pr__nfet_01v8[id]
print @m.xm2.msky130_fd_pr__nfet_01v8[gm]
print @m.xm2.msky130_fd_pr__nfet_01v8[gds]
print @m.xm2.msky130_fd_pr__nfet_01v8[vth]
print @m.xm2.msky130_fd_pr__nfet_01v8[vdsat]
print @m.xm2.msky130_fd_pr__nfet_01v8[vgs]
print @m.xm2.msky130_fd_pr__nfet_01v8[vds]
print @m.xm2.msky130_fd_pr__nfet_01v8[vbs]
print @m.xm3.msky130_fd_pr__pfet_01v8[id]
print @m.xm3.msky130_fd_pr__pfet_01v8[gm]
print @m.xm3.msky130_fd_pr__pfet_01v8[gds]
print @m.xm3.msky130_fd_pr__pfet_01v8[vth]
print @m.xm3.msky130_fd_pr__pfet_01v8[vdsat]
print @m.xm3.msky130_fd_pr__pfet_01v8[vgs]
print @m.xm3.msky130_fd_pr__pfet_01v8[vds]
print @m.xm3.msky130_fd_pr__pfet_01v8[vbs]
print @m.xm4.msky130_fd_pr__pfet_01v8[id]
print @m.xm4.msky130_fd_pr__pfet_01v8[gm]
print @m.xm4.msky130_fd_pr__pfet_01v8[gds]
print @m.xm4.msky130_fd_pr__pfet_01v8[vth]
print @m.xm4.msky130_fd_pr__pfet_01v8[vdsat]
print @m.xm4.msky130_fd_pr__pfet_01v8[vgs]
print @m.xm4.msky130_fd_pr__pfet_01v8[vds]
print @m.xm4.msky130_fd_pr__pfet_01v8[vbs]
print v(d1)
print v(inp)
print v(tail)
print v(out)
print v(inn)
print v(vdd)
print i(vrail_vdd)
echo OPEND
alter vofs_inn dc = -0.589413521429
alter vdc_inp dc = 1.49344452143
echo SWP 59
op
echo OPSTART
print @m.xm1.msky130_fd_pr__nfet_01v8[id]
print @m.xm1.msky130_fd_pr__nfet_01v8[gm]
print @m.xm1.msky130_fd_pr__nfet_01v8[gds]
print @m.xm1.msky130_fd_pr__nfet_01v8[vth]
print @m.xm1.msky130_fd_pr__nfet_01v8[vdsat]
print @m.xm1.msky130_fd_pr__nfet_01v8[vgs]
print @m.xm1.msky130_fd_pr__nfet_01v8[vds]
print @m.xm1.msky130_fd_pr__nfet_01v8[vbs]
print @m.xm2.msky130_fd_pr__nfet_01v8[id]
print @m.xm2.msky130_fd_pr__nfet_01v8[gm]
print @m.xm2.msky130_fd_pr__nfet_01v8[gds]
print @m.xm2.msky130_fd_pr__nfet_01v8[vth]
print @m.xm2.msky130_fd_pr__nfet_01v8[vdsat]
print @m.xm2.msky130_fd_pr__nfet_01v8[vgs]
print @m.xm2.msky130_fd_pr__nfet_01v8[vds]
print @m.xm2.msky130_fd_pr__nfet_01v8[vbs]
print @m.xm3.msky130_fd_pr__pfet_01v8[id]
print @m.xm3.msky130_fd_pr__pfet_01v8[gm]
print @m.xm3.msky130_fd_pr__pfet_01v8[gds]
print @m.xm3.msky130_fd_pr__pfet_01v8[vth]
print @m.xm3.msky130_fd_pr__pfet_01v8[vdsat]
print @m.xm3.msky130_fd_pr__pfet_01v8[vgs]
print @m.xm3.msky130_fd_pr__pfet_01v8[vds]
print @m.xm3.msky130_fd_pr__pfet_01v8[vbs]
print @m.xm4.msky130_fd_pr__pfet_01v8[id]
print @m.xm4.msky130_fd_pr__pfet_01v8[gm]
print @m.xm4.msky130_fd_pr__pfet_01v8[gds]
print @m.xm4.msky130_fd_pr__pfet_01v8[vth]
print @m.xm4.msky130_fd_pr__pfet_01v8[vdsat]
print @m.xm4.msky130_fd_pr__pfet_01v8[vgs]
print @m.xm4.msky130_fd_pr__pfet_01v8[vds]
print @m.xm4.msky130_fd_pr__pfet_01v8[vbs]
print v(d1)
print v(inp)
print v(tail)
print v(out)
print v(inn)
print v(vdd)
print i(vrail_vdd)
echo OPEND
alter vofs_inn dc = -0.615127807143
alter vdc_inp dc = 1.51915880714
echo SWP 60
op
echo OPSTART
print @m.xm1.msky130_fd_pr__nfet_01v8[id]
print @m.xm1.msky130_fd_pr__nfet_01v8[gm]
print @m.xm1.msky130_fd_pr__nfet_01v8[gds]
print @m.xm1.msky130_fd_pr__nfet_01v8[vth]
print @m.xm1.msky130_fd_pr__nfet_01v8[vdsat]
print @m.xm1.msky130_fd_pr__nfet_01v8[vgs]
print @m.xm1.msky130_fd_pr__nfet_01v8[vds]
print @m.xm1.msky130_fd_pr__nfet_01v8[vbs]
print @m.xm2.msky130_fd_pr__nfet_01v8[id]
print @m.xm2.msky130_fd_pr__nfet_01v8[gm]
print @m.xm2.msky130_fd_pr__nfet_01v8[gds]
print @m.xm2.msky130_fd_pr__nfet_01v8[vth]
print @m.xm2.msky130_fd_pr__nfet_01v8[vdsat]
print @m.xm2.msky130_fd_pr__nfet_01v8[vgs]
print @m.xm2.msky130_fd_pr__nfet_01v8[vds]
print @m.xm2.msky130_fd_pr__nfet_01v8[vbs]
print @m.xm3.msky130_fd_pr__pfet_01v8[id]
print @m.xm3.msky130_fd_pr__pfet_01v8[gm]
print @m.xm3.msky130_fd_pr__pfet_01v8[gds]
print @m.xm3.msky130_fd_pr__pfet_01v8[vth]
print @m.xm3.msky130_fd_pr__pfet_01v8[vdsat]
print @m.xm3.msky130_fd_pr__pfet_01v8[vgs]
print @m.xm3.msky130_fd_pr__pfet_01v8[vds]
print @m.xm3.msky130_fd_pr__pfet_01v8[vbs]
print @m.xm4.msky130_fd_pr__pfet_01v8[id]
print @m.xm4.msky130_fd_pr__pfet_01v8[gm]
print @m.xm4.msky130_fd_pr__pfet_01v8[gds]
print @m.xm4.msky130_fd_pr__pfet_01v8[vth]
print @m.xm4.msky130_fd_pr__pfet_01v8[vdsat]
print @m.xm4.msky130_fd_pr__pfet_01v8[vgs]
print @m.xm4.msky130_fd_pr__pfet_01v8[vds]
print @m.xm4.msky130_fd_pr__pfet_01v8[vbs]
print v(d1)
print v(inp)
print v(tail)
print v(out)
print v(inn)
print v(vdd)
print i(vrail_vdd)
echo OPEND
alter vofs_inn dc = -0.640842092857
alter vdc_inp dc = 1.54487309286
echo SWP 61
op
echo OPSTART
print @m.xm1.msky130_fd_pr__nfet_01v8[id]
print @m.xm1.msky130_fd_pr__nfet_01v8[gm]
print @m.xm1.msky130_fd_pr__nfet_01v8[gds]
print @m.xm1.msky130_fd_pr__nfet_01v8[vth]
print @m.xm1.msky130_fd_pr__nfet_01v8[vdsat]
print @m.xm1.msky130_fd_pr__nfet_01v8[vgs]
print @m.xm1.msky130_fd_pr__nfet_01v8[vds]
print @m.xm1.msky130_fd_pr__nfet_01v8[vbs]
print @m.xm2.msky130_fd_pr__nfet_01v8[id]
print @m.xm2.msky130_fd_pr__nfet_01v8[gm]
print @m.xm2.msky130_fd_pr__nfet_01v8[gds]
print @m.xm2.msky130_fd_pr__nfet_01v8[vth]
print @m.xm2.msky130_fd_pr__nfet_01v8[vdsat]
print @m.xm2.msky130_fd_pr__nfet_01v8[vgs]
print @m.xm2.msky130_fd_pr__nfet_01v8[vds]
print @m.xm2.msky130_fd_pr__nfet_01v8[vbs]
print @m.xm3.msky130_fd_pr__pfet_01v8[id]
print @m.xm3.msky130_fd_pr__pfet_01v8[gm]
print @m.xm3.msky130_fd_pr__pfet_01v8[gds]
print @m.xm3.msky130_fd_pr__pfet_01v8[vth]
print @m.xm3.msky130_fd_pr__pfet_01v8[vdsat]
print @m.xm3.msky130_fd_pr__pfet_01v8[vgs]
print @m.xm3.msky130_fd_pr__pfet_01v8[vds]
print @m.xm3.msky130_fd_pr__pfet_01v8[vbs]
print @m.xm4.msky130_fd_pr__pfet_01v8[id]
print @m.xm4.msky130_fd_pr__pfet_01v8[gm]
print @m.xm4.msky130_fd_pr__pfet_01v8[gds]
print @m.xm4.msky130_fd_pr__pfet_01v8[vth]
print @m.xm4.msky130_fd_pr__pfet_01v8[vdsat]
print @m.xm4.msky130_fd_pr__pfet_01v8[vgs]
print @m.xm4.msky130_fd_pr__pfet_01v8[vds]
print @m.xm4.msky130_fd_pr__pfet_01v8[vbs]
print v(d1)
print v(inp)
print v(tail)
print v(out)
print v(inn)
print v(vdd)
print i(vrail_vdd)
echo OPEND
alter vofs_inn dc = -0.666556378571
alter vdc_inp dc = 1.57058737857
echo SWP 62
op
echo OPSTART
print @m.xm1.msky130_fd_pr__nfet_01v8[id]
print @m.xm1.msky130_fd_pr__nfet_01v8[gm]
print @m.xm1.msky130_fd_pr__nfet_01v8[gds]
print @m.xm1.msky130_fd_pr__nfet_01v8[vth]
print @m.xm1.msky130_fd_pr__nfet_01v8[vdsat]
print @m.xm1.msky130_fd_pr__nfet_01v8[vgs]
print @m.xm1.msky130_fd_pr__nfet_01v8[vds]
print @m.xm1.msky130_fd_pr__nfet_01v8[vbs]
print @m.xm2.msky130_fd_pr__nfet_01v8[id]
print @m.xm2.msky130_fd_pr__nfet_01v8[gm]
print @m.xm2.msky130_fd_pr__nfet_01v8[gds]
print @m.xm2.msky130_fd_pr__nfet_01v8[vth]
print @m.xm2.msky130_fd_pr__nfet_01v8[vdsat]
print @m.xm2.msky130_fd_pr__nfet_01v8[vgs]
print @m.xm2.msky130_fd_pr__nfet_01v8[vds]
print @m.xm2.msky130_fd_pr__nfet_01v8[vbs]
print @m.xm3.msky130_fd_pr__pfet_01v8[id]
print @m.xm3.msky130_fd_pr__pfet_01v8[gm]
print @m.xm3.msky130_fd_pr__pfet_01v8[gds]
print @m.xm3.msky130_fd_pr__pfet_01v8[vth]
print @m.xm3.msky130_fd_pr__pfet_01v8[vdsat]
print @m.xm3.msky130_fd_pr__pfet_01v8[vgs]
print @m.xm3.msky130_fd_pr__pfet_01v8[vds]
print @m.xm3.msky130_fd_pr__pfet_01v8[vbs]
print @m.xm4.msky130_fd_pr__pfet_01v8[id]
print @m.xm4.msky130_fd_pr__pfet_01v8[gm]
print @m.xm4.msky130_fd_pr__pfet_01v8[gds]
print @m.xm4.msky130_fd_pr__pfet_01v8[vth]
print @m.xm4.msky130_fd_pr__pfet_01v8[vdsat]
print @m.xm4.msky130_fd_pr__pfet_01v8[vgs]
print @m.xm4.msky130_fd_pr__pfet_01v8[vds]
print @m.xm4.msky130_fd_pr__pfet_01v8[vbs]
print v(d1)
print v(inp)
print v(tail)
print v(out)
print v(inn)
print v(vdd)
print i(vrail_vdd)
echo OPEND
alter vofs_inn dc = -0.692270664286
alter vdc_inp dc = 1.59630166429
echo SWP 63
op
echo OPSTART
print @m.xm1.msky130_fd_pr__nfet_01v8[id]
print @m.xm1.msky130_fd_pr__nfet_01v8[gm]
print @m.xm1.msky130_fd_pr__nfet_01v8[gds]
print @m.xm1.msky130_fd_pr__nfet_01v8[vth]
print @m.xm1.msky130_fd_pr__nfet_01v8[vdsat]
print @m.xm1.msky130_fd_pr__nfet_01v8[vgs]
print @m.xm1.msky130_fd_pr__nfet_01v8[vds]
print @m.xm1.msky130_fd_pr__nfet_01v8[vbs]
print @m.xm2.msky130_fd_pr__nfet_01v8[id]
print @m.xm2.msky130_fd_pr__nfet_01v8[gm]
print @m.xm2.msky130_fd_pr__nfet_01v8[gds]
print @m.xm2.msky130_fd_pr__nfet_01v8[vth]
print @m.xm2.msky130_fd_pr__nfet_01v8[vdsat]
print @m.xm2.msky130_fd_pr__nfet_01v8[vgs]
print @m.xm2.msky130_fd_pr__nfet_01v8[vds]
print @m.xm2.msky130_fd_pr__nfet_01v8[vbs]
print @m.xm3.msky130_fd_pr__pfet_01v8[id]
print @m.xm3.msky130_fd_pr__pfet_01v8[gm]
print @m.xm3.msky130_fd_pr__pfet_01v8[gds]
print @m.xm3.msky130_fd_pr__pfet_01v8[vth]
print @m.xm3.msky130_fd_pr__pfet_01v8[vdsat]
print @m.xm3.msky130_fd_pr__pfet_01v8[vgs]
print @m.xm3.msky130_fd_pr__pfet_01v8[vds]
print @m.xm3.msky130_fd_pr__pfet_01v8[vbs]
print @m.xm4.msky130_fd_pr__pfet_01v8[id]
print @m.xm4.msky130_fd_pr__pfet_01v8[gm]
print @m.xm4.msky130_fd_pr__pfet_01v8[gds]
print @m.xm4.msky130_fd_pr__pfet_01v8[vth]
print @m.xm4.msky130_fd_pr__pfet_01v8[vdsat]
print @m.xm4.msky130_fd_pr__pfet_01v8[vgs]
print @m.xm4.msky130_fd_pr__pfet_01v8[vds]
print @m.xm4.msky130_fd_pr__pfet_01v8[vbs]
print v(d1)
print v(inp)
print v(tail)
print v(out)
print v(inn)
print v(vdd)
print i(vrail_vdd)
echo OPEND
alter vofs_inn dc = -0.71798495
alter vdc_inp dc = 1.62201595
echo SWP 64
op
echo OPSTART
print @m.xm1.msky130_fd_pr__nfet_01v8[id]
print @m.xm1.msky130_fd_pr__nfet_01v8[gm]
print @m.xm1.msky130_fd_pr__nfet_01v8[gds]
print @m.xm1.msky130_fd_pr__nfet_01v8[vth]
print @m.xm1.msky130_fd_pr__nfet_01v8[vdsat]
print @m.xm1.msky130_fd_pr__nfet_01v8[vgs]
print @m.xm1.msky130_fd_pr__nfet_01v8[vds]
print @m.xm1.msky130_fd_pr__nfet_01v8[vbs]
print @m.xm2.msky130_fd_pr__nfet_01v8[id]
print @m.xm2.msky130_fd_pr__nfet_01v8[gm]
print @m.xm2.msky130_fd_pr__nfet_01v8[gds]
print @m.xm2.msky130_fd_pr__nfet_01v8[vth]
print @m.xm2.msky130_fd_pr__nfet_01v8[vdsat]
print @m.xm2.msky130_fd_pr__nfet_01v8[vgs]
print @m.xm2.msky130_fd_pr__nfet_01v8[vds]
print @m.xm2.msky130_fd_pr__nfet_01v8[vbs]
print @m.xm3.msky130_fd_pr__pfet_01v8[id]
print @m.xm3.msky130_fd_pr__pfet_01v8[gm]
print @m.xm3.msky130_fd_pr__pfet_01v8[gds]
print @m.xm3.msky130_fd_pr__pfet_01v8[vth]
print @m.xm3.msky130_fd_pr__pfet_01v8[vdsat]
print @m.xm3.msky130_fd_pr__pfet_01v8[vgs]
print @m.xm3.msky130_fd_pr__pfet_01v8[vds]
print @m.xm3.msky130_fd_pr__pfet_01v8[vbs]
print @m.xm4.msky130_fd_pr__pfet_01v8[id]
print @m.xm4.msky130_fd_pr__pfet_01v8[gm]
print @m.xm4.msky130_fd_pr__pfet_01v8[gds]
print @m.xm4.msky130_fd_pr__pfet_01v8[vth]
print @m.xm4.msky130_fd_pr__pfet_01v8[vdsat]
print @m.xm4.msky130_fd_pr__pfet_01v8[vgs]
print @m.xm4.msky130_fd_pr__pfet_01v8[vds]
print @m.xm4.msky130_fd_pr__pfet_01v8[vbs]
print v(d1)
print v(inp)
print v(tail)
print v(out)
print v(inn)
print v(vdd)
print i(vrail_vdd)
echo OPEND
alter vofs_inn dc = -0.743699235714
alter vdc_inp dc = 1.64773023571
echo SWP 65
op
echo OPSTART
print @m.xm1.msky130_fd_pr__nfet_01v8[id]
print @m.xm1.msky130_fd_pr__nfet_01v8[gm]
print @m.xm1.msky130_fd_pr__nfet_01v8[gds]
print @m.xm1.msky130_fd_pr__nfet_01v8[vth]
print @m.xm1.msky130_fd_pr__nfet_01v8[vdsat]
print @m.xm1.msky130_fd_pr__nfet_01v8[vgs]
print @m.xm1.msky130_fd_pr__nfet_01v8[vds]
print @m.xm1.msky130_fd_pr__nfet_01v8[vbs]
print @m.xm2.msky130_fd_pr__nfet_01v8[id]
print @m.xm2.msky130_fd_pr__nfet_01v8[gm]
print @m.xm2.msky130_fd_pr__nfet_01v8[gds]
print @m.xm2.msky130_fd_pr__nfet_01v8[vth]
print @m.xm2.msky130_fd_pr__nfet_01v8[vdsat]
print @m.xm2.msky130_fd_pr__nfet_01v8[vgs]
print @m.xm2.msky130_fd_pr__nfet_01v8[vds]
print @m.xm2.msky130_fd_pr__nfet_01v8[vbs]
print @m.xm3.msky130_fd_pr__pfet_01v8[id]
print @m.xm3.msky130_fd_pr__pfet_01v8[gm]
print @m.xm3.msky130_fd_pr__pfet_01v8[gds]
print @m.xm3.msky130_fd_pr__pfet_01v8[vth]
print @m.xm3.msky130_fd_pr__pfet_01v8[vdsat]
print @m.xm3.msky130_fd_pr__pfet_01v8[vgs]
print @m.xm3.msky130_fd_pr__pfet_01v8[vds]
print @m.xm3.msky130_fd_pr__pfet_01v8[vbs]
print @m.xm4.msky130_fd_pr__pfet_01v8[id]
print @m.xm4.msky130_fd_pr__pfet_01v8[gm]
print @m.xm4.msky130_fd_pr__pfet_01v8[gds]
print @m.xm4.msky130_fd_pr__pfet_01v8[vth]
print @m.xm4.msky130_fd_pr__pfet_01v8[vdsat]
print @m.xm4.msky130_fd_pr__pfet_01v8[vgs]
print @m.xm4.msky130_fd_pr__pfet_01v8[vds]
print @m.xm4.msky130_fd_pr__pfet_01v8[vbs]
print v(d1)
print v(inp)
print v(tail)
print v(out)
print v(inn)
print v(vdd)
print i(vrail_vdd)
echo OPEND
alter vofs_inn dc = -0.769413521429
alter vdc_inp dc = 1.67344452143
echo SWP 66
op
echo OPSTART
print @m.xm1.msky130_fd_pr__nfet_01v8[id]
print @m.xm1.msky130_fd_pr__nfet_01v8[gm]
print @m.xm1.msky130_fd_pr__nfet_01v8[gds]
print @m.xm1.msky130_fd_pr__nfet_01v8[vth]
print @m.xm1.msky130_fd_pr__nfet_01v8[vdsat]
print @m.xm1.msky130_fd_pr__nfet_01v8[vgs]
print @m.xm1.msky130_fd_pr__nfet_01v8[vds]
print @m.xm1.msky130_fd_pr__nfet_01v8[vbs]
print @m.xm2.msky130_fd_pr__nfet_01v8[id]
print @m.xm2.msky130_fd_pr__nfet_01v8[gm]
print @m.xm2.msky130_fd_pr__nfet_01v8[gds]
print @m.xm2.msky130_fd_pr__nfet_01v8[vth]
print @m.xm2.msky130_fd_pr__nfet_01v8[vdsat]
print @m.xm2.msky130_fd_pr__nfet_01v8[vgs]
print @m.xm2.msky130_fd_pr__nfet_01v8[vds]
print @m.xm2.msky130_fd_pr__nfet_01v8[vbs]
print @m.xm3.msky130_fd_pr__pfet_01v8[id]
print @m.xm3.msky130_fd_pr__pfet_01v8[gm]
print @m.xm3.msky130_fd_pr__pfet_01v8[gds]
print @m.xm3.msky130_fd_pr__pfet_01v8[vth]
print @m.xm3.msky130_fd_pr__pfet_01v8[vdsat]
print @m.xm3.msky130_fd_pr__pfet_01v8[vgs]
print @m.xm3.msky130_fd_pr__pfet_01v8[vds]
print @m.xm3.msky130_fd_pr__pfet_01v8[vbs]
print @m.xm4.msky130_fd_pr__pfet_01v8[id]
print @m.xm4.msky130_fd_pr__pfet_01v8[gm]
print @m.xm4.msky130_fd_pr__pfet_01v8[gds]
print @m.xm4.msky130_fd_pr__pfet_01v8[vth]
print @m.xm4.msky130_fd_pr__pfet_01v8[vdsat]
print @m.xm4.msky130_fd_pr__pfet_01v8[vgs]
print @m.xm4.msky130_fd_pr__pfet_01v8[vds]
print @m.xm4.msky130_fd_pr__pfet_01v8[vbs]
print v(d1)
print v(inp)
print v(tail)
print v(out)
print v(inn)
print v(vdd)
print i(vrail_vdd)
echo OPEND
alter vofs_inn dc = -0.795127807143
alter vdc_inp dc = 1.69915880714
echo SWP 67
op
echo OPSTART
print @m.xm1.msky130_fd_pr__nfet_01v8[id]
print @m.xm1.msky130_fd_pr__nfet_01v8[gm]
print @m.xm1.msky130_fd_pr__nfet_01v8[gds]
print @m.xm1.msky130_fd_pr__nfet_01v8[vth]
print @m.xm1.msky130_fd_pr__nfet_01v8[vdsat]
print @m.xm1.msky130_fd_pr__nfet_01v8[vgs]
print @m.xm1.msky130_fd_pr__nfet_01v8[vds]
print @m.xm1.msky130_fd_pr__nfet_01v8[vbs]
print @m.xm2.msky130_fd_pr__nfet_01v8[id]
print @m.xm2.msky130_fd_pr__nfet_01v8[gm]
print @m.xm2.msky130_fd_pr__nfet_01v8[gds]
print @m.xm2.msky130_fd_pr__nfet_01v8[vth]
print @m.xm2.msky130_fd_pr__nfet_01v8[vdsat]
print @m.xm2.msky130_fd_pr__nfet_01v8[vgs]
print @m.xm2.msky130_fd_pr__nfet_01v8[vds]
print @m.xm2.msky130_fd_pr__nfet_01v8[vbs]
print @m.xm3.msky130_fd_pr__pfet_01v8[id]
print @m.xm3.msky130_fd_pr__pfet_01v8[gm]
print @m.xm3.msky130_fd_pr__pfet_01v8[gds]
print @m.xm3.msky130_fd_pr__pfet_01v8[vth]
print @m.xm3.msky130_fd_pr__pfet_01v8[vdsat]
print @m.xm3.msky130_fd_pr__pfet_01v8[vgs]
print @m.xm3.msky130_fd_pr__pfet_01v8[vds]
print @m.xm3.msky130_fd_pr__pfet_01v8[vbs]
print @m.xm4.msky130_fd_pr__pfet_01v8[id]
print @m.xm4.msky130_fd_pr__pfet_01v8[gm]
print @m.xm4.msky130_fd_pr__pfet_01v8[gds]
print @m.xm4.msky130_fd_pr__pfet_01v8[vth]
print @m.xm4.msky130_fd_pr__pfet_01v8[vdsat]
print @m.xm4.msky130_fd_pr__pfet_01v8[vgs]
print @m.xm4.msky130_fd_pr__pfet_01v8[vds]
print @m.xm4.msky130_fd_pr__pfet_01v8[vbs]
print v(d1)
print v(inp)
print v(tail)
print v(out)
print v(inn)
print v(vdd)
print i(vrail_vdd)
echo OPEND
alter vofs_inn dc = -0.820842092857
alter vdc_inp dc = 1.72487309286
echo SWP 68
op
echo OPSTART
print @m.xm1.msky130_fd_pr__nfet_01v8[id]
print @m.xm1.msky130_fd_pr__nfet_01v8[gm]
print @m.xm1.msky130_fd_pr__nfet_01v8[gds]
print @m.xm1.msky130_fd_pr__nfet_01v8[vth]
print @m.xm1.msky130_fd_pr__nfet_01v8[vdsat]
print @m.xm1.msky130_fd_pr__nfet_01v8[vgs]
print @m.xm1.msky130_fd_pr__nfet_01v8[vds]
print @m.xm1.msky130_fd_pr__nfet_01v8[vbs]
print @m.xm2.msky130_fd_pr__nfet_01v8[id]
print @m.xm2.msky130_fd_pr__nfet_01v8[gm]
print @m.xm2.msky130_fd_pr__nfet_01v8[gds]
print @m.xm2.msky130_fd_pr__nfet_01v8[vth]
print @m.xm2.msky130_fd_pr__nfet_01v8[vdsat]
print @m.xm2.msky130_fd_pr__nfet_01v8[vgs]
print @m.xm2.msky130_fd_pr__nfet_01v8[vds]
print @m.xm2.msky130_fd_pr__nfet_01v8[vbs]
print @m.xm3.msky130_fd_pr__pfet_01v8[id]
print @m.xm3.msky130_fd_pr__pfet_01v8[gm]
print @m.xm3.msky130_fd_pr__pfet_01v8[gds]
print @m.xm3.msky130_fd_pr__pfet_01v8[vth]
print @m.xm3.msky130_fd_pr__pfet_01v8[vdsat]
print @m.xm3.msky130_fd_pr__pfet_01v8[vgs]
print @m.xm3.msky130_fd_pr__pfet_01v8[vds]
print @m.xm3.msky130_fd_pr__pfet_01v8[vbs]
print @m.xm4.msky130_fd_pr__pfet_01v8[id]
print @m.xm4.msky130_fd_pr__pfet_01v8[gm]
print @m.xm4.msky130_fd_pr__pfet_01v8[gds]
print @m.xm4.msky130_fd_pr__pfet_01v8[vth]
print @m.xm4.msky130_fd_pr__pfet_01v8[vdsat]
print @m.xm4.msky130_fd_pr__pfet_01v8[vgs]
print @m.xm4.msky130_fd_pr__pfet_01v8[vds]
print @m.xm4.msky130_fd_pr__pfet_01v8[vbs]
print v(d1)
print v(inp)
print v(tail)
print v(out)
print v(inn)
print v(vdd)
print i(vrail_vdd)
echo OPEND
alter vofs_inn dc = -0.846556378571
alter vdc_inp dc = 1.75058737857
echo SWP 69
op
echo OPSTART
print @m.xm1.msky130_fd_pr__nfet_01v8[id]
print @m.xm1.msky130_fd_pr__nfet_01v8[gm]
print @m.xm1.msky130_fd_pr__nfet_01v8[gds]
print @m.xm1.msky130_fd_pr__nfet_01v8[vth]
print @m.xm1.msky130_fd_pr__nfet_01v8[vdsat]
print @m.xm1.msky130_fd_pr__nfet_01v8[vgs]
print @m.xm1.msky130_fd_pr__nfet_01v8[vds]
print @m.xm1.msky130_fd_pr__nfet_01v8[vbs]
print @m.xm2.msky130_fd_pr__nfet_01v8[id]
print @m.xm2.msky130_fd_pr__nfet_01v8[gm]
print @m.xm2.msky130_fd_pr__nfet_01v8[gds]
print @m.xm2.msky130_fd_pr__nfet_01v8[vth]
print @m.xm2.msky130_fd_pr__nfet_01v8[vdsat]
print @m.xm2.msky130_fd_pr__nfet_01v8[vgs]
print @m.xm2.msky130_fd_pr__nfet_01v8[vds]
print @m.xm2.msky130_fd_pr__nfet_01v8[vbs]
print @m.xm3.msky130_fd_pr__pfet_01v8[id]
print @m.xm3.msky130_fd_pr__pfet_01v8[gm]
print @m.xm3.msky130_fd_pr__pfet_01v8[gds]
print @m.xm3.msky130_fd_pr__pfet_01v8[vth]
print @m.xm3.msky130_fd_pr__pfet_01v8[vdsat]
print @m.xm3.msky130_fd_pr__pfet_01v8[vgs]
print @m.xm3.msky130_fd_pr__pfet_01v8[vds]
print @m.xm3.msky130_fd_pr__pfet_01v8[vbs]
print @m.xm4.msky130_fd_pr__pfet_01v8[id]
print @m.xm4.msky130_fd_pr__pfet_01v8[gm]
print @m.xm4.msky130_fd_pr__pfet_01v8[gds]
print @m.xm4.msky130_fd_pr__pfet_01v8[vth]
print @m.xm4.msky130_fd_pr__pfet_01v8[vdsat]
print @m.xm4.msky130_fd_pr__pfet_01v8[vgs]
print @m.xm4.msky130_fd_pr__pfet_01v8[vds]
print @m.xm4.msky130_fd_pr__pfet_01v8[vbs]
print v(d1)
print v(inp)
print v(tail)
print v(out)
print v(inn)
print v(vdd)
print i(vrail_vdd)
echo OPEND
alter vofs_inn dc = -0.872270664286
alter vdc_inp dc = 1.77630166429
echo SWP 70
op
echo OPSTART
print @m.xm1.msky130_fd_pr__nfet_01v8[id]
print @m.xm1.msky130_fd_pr__nfet_01v8[gm]
print @m.xm1.msky130_fd_pr__nfet_01v8[gds]
print @m.xm1.msky130_fd_pr__nfet_01v8[vth]
print @m.xm1.msky130_fd_pr__nfet_01v8[vdsat]
print @m.xm1.msky130_fd_pr__nfet_01v8[vgs]
print @m.xm1.msky130_fd_pr__nfet_01v8[vds]
print @m.xm1.msky130_fd_pr__nfet_01v8[vbs]
print @m.xm2.msky130_fd_pr__nfet_01v8[id]
print @m.xm2.msky130_fd_pr__nfet_01v8[gm]
print @m.xm2.msky130_fd_pr__nfet_01v8[gds]
print @m.xm2.msky130_fd_pr__nfet_01v8[vth]
print @m.xm2.msky130_fd_pr__nfet_01v8[vdsat]
print @m.xm2.msky130_fd_pr__nfet_01v8[vgs]
print @m.xm2.msky130_fd_pr__nfet_01v8[vds]
print @m.xm2.msky130_fd_pr__nfet_01v8[vbs]
print @m.xm3.msky130_fd_pr__pfet_01v8[id]
print @m.xm3.msky130_fd_pr__pfet_01v8[gm]
print @m.xm3.msky130_fd_pr__pfet_01v8[gds]
print @m.xm3.msky130_fd_pr__pfet_01v8[vth]
print @m.xm3.msky130_fd_pr__pfet_01v8[vdsat]
print @m.xm3.msky130_fd_pr__pfet_01v8[vgs]
print @m.xm3.msky130_fd_pr__pfet_01v8[vds]
print @m.xm3.msky130_fd_pr__pfet_01v8[vbs]
print @m.xm4.msky130_fd_pr__pfet_01v8[id]
print @m.xm4.msky130_fd_pr__pfet_01v8[gm]
print @m.xm4.msky130_fd_pr__pfet_01v8[gds]
print @m.xm4.msky130_fd_pr__pfet_01v8[vth]
print @m.xm4.msky130_fd_pr__pfet_01v8[vdsat]
print @m.xm4.msky130_fd_pr__pfet_01v8[vgs]
print @m.xm4.msky130_fd_pr__pfet_01v8[vds]
print @m.xm4.msky130_fd_pr__pfet_01v8[vbs]
print v(d1)
print v(inp)
print v(tail)
print v(out)
print v(inn)
print v(vdd)
print i(vrail_vdd)
echo OPEND
alter vofs_inn dc = -0.89798495
alter vdc_inp dc = 1.80201595
echo SWP 71
op
echo OPSTART
print @m.xm1.msky130_fd_pr__nfet_01v8[id]
print @m.xm1.msky130_fd_pr__nfet_01v8[gm]
print @m.xm1.msky130_fd_pr__nfet_01v8[gds]
print @m.xm1.msky130_fd_pr__nfet_01v8[vth]
print @m.xm1.msky130_fd_pr__nfet_01v8[vdsat]
print @m.xm1.msky130_fd_pr__nfet_01v8[vgs]
print @m.xm1.msky130_fd_pr__nfet_01v8[vds]
print @m.xm1.msky130_fd_pr__nfet_01v8[vbs]
print @m.xm2.msky130_fd_pr__nfet_01v8[id]
print @m.xm2.msky130_fd_pr__nfet_01v8[gm]
print @m.xm2.msky130_fd_pr__nfet_01v8[gds]
print @m.xm2.msky130_fd_pr__nfet_01v8[vth]
print @m.xm2.msky130_fd_pr__nfet_01v8[vdsat]
print @m.xm2.msky130_fd_pr__nfet_01v8[vgs]
print @m.xm2.msky130_fd_pr__nfet_01v8[vds]
print @m.xm2.msky130_fd_pr__nfet_01v8[vbs]
print @m.xm3.msky130_fd_pr__pfet_01v8[id]
print @m.xm3.msky130_fd_pr__pfet_01v8[gm]
print @m.xm3.msky130_fd_pr__pfet_01v8[gds]
print @m.xm3.msky130_fd_pr__pfet_01v8[vth]
print @m.xm3.msky130_fd_pr__pfet_01v8[vdsat]
print @m.xm3.msky130_fd_pr__pfet_01v8[vgs]
print @m.xm3.msky130_fd_pr__pfet_01v8[vds]
print @m.xm3.msky130_fd_pr__pfet_01v8[vbs]
print @m.xm4.msky130_fd_pr__pfet_01v8[id]
print @m.xm4.msky130_fd_pr__pfet_01v8[gm]
print @m.xm4.msky130_fd_pr__pfet_01v8[gds]
print @m.xm4.msky130_fd_pr__pfet_01v8[vth]
print @m.xm4.msky130_fd_pr__pfet_01v8[vdsat]
print @m.xm4.msky130_fd_pr__pfet_01v8[vgs]
print @m.xm4.msky130_fd_pr__pfet_01v8[vds]
print @m.xm4.msky130_fd_pr__pfet_01v8[vbs]
print v(d1)
print v(inp)
print v(tail)
print v(out)
print v(inn)
print v(vdd)
print i(vrail_vdd)
echo OPEND
quit
.endc
.end
