* spice_oracle: trhp_posfb bias=free
.include "C:/pdk/sky130_fd_pr/cells/nfet_01v8/sky130_fd_pr__nfet_01v8__tt.pm3.spice"
.include "C:/pdk/sky130_fd_pr/cells/nfet_01v8/sky130_fd_pr__nfet_01v8__mismatch.corner.spice"
.temp 27
.option gmin=1e-15 reltol=1e-4 abstol=1e-14 vntol=1e-7
Vrail_vdd vdd 0 DC 1.8
Vrail_vb vb 0 DC 0.7
XM1 n1 nin 0 0 sky130_fd_pr__nfet_01v8 l=5e-07 w=2e-06 m=1 ad=0 as=0 pd=0 ps=0
XM2 n2 n1 0 0 sky130_fd_pr__nfet_01v8 l=5e-07 w=2e-06 m=2 ad=0 as=0 pd=0 ps=0
XM3 n1 n3 0 0 sky130_fd_pr__nfet_01v8 l=5e-07 w=2e-06 m=4 ad=0 as=0 pd=0 ps=0
Rp_R1 vdd n1 51764.70588
Rp_R2 vdd n2 129400
Rp_Rb vb n3 100000
Cp_Cc n2 n3 1e-12
Vdc_nin dcs_nin 0 DC 0.7
Ldc_nin dcs_nin nin 1e+12
Cac_nin nin acs_nin 1
Vac_nin acs_nin 0 DC 0 AC 1
.control
set noaskquit
op
echo OPSTART
print @m.xm1.msky130_fd_pr__nfet_01v8[id]
print @m.xm1.msky130_fd_pr__nfet_01v8[gm]
print @m.xm1.msky130_fd_pr__nfet_01v8[gds]
print @m.xm1.msky130_fd_pr__nfet_01v8[vth]
print @m.xm1.msky130_fd_pr__nfet_01v8[vdsat]
print @m.xm1.msky130_fd_pr__nfet_01v8[vgs]
print @m.xm1.msky130_fd_pr__nfet_01v8[vds]
print @m.xm1.msky130_fd_pr__nfet_01v8[vbs]
print @m.xm2.msky130_fd_pr__nfet_01v8[id]
print @m.xm2.msky130_fd_pr__nfet_01v8[gm]
print @m.xm2.msky130_fd_pr__nfet_01v8[gds]
print @m.xm2.msky130_fd_pr__nfet_01v8[vth]
print @m.xm2.msky130_fd_pr__nfet_01v8[vdsat]
print @m.xm2.msky130_fd_pr__nfet_01v8[vgs]
print @m.xm2.msky130_fd_pr__nfet_01v8[vds]
print @m.xm2.msky130_fd_pr__nfet_01v8[vbs]
print @m.xm3.msky130_fd_pr__nfet_01v8[id]
print @m.xm3.msky130_fd_pr__nfet_01v8[gm]
print @m.xm3.msky130_fd_pr__nfet_01v8[gds]
print @m.xm3.msky130_fd_pr__nfet_01v8[vth]
print @m.xm3.msky130_fd_pr__nfet_01v8[vdsat]
print @m.xm3.msky130_fd_pr__nfet_01v8[vgs]
print @m.xm3.msky130_fd_pr__nfet_01v8[vds]
print @m.xm3.msky130_fd_pr__nfet_01v8[vbs]
print v(n1)
print v(nin)
print v(n2)
print v(n3)
print v(vdd)
print v(vb)
print i(vrail_vdd)
print i(vrail_vb)
echo OPEND
ac dec 40 0.01 1e+10
let hout = v(n2)
set wr_singlescale
wrdata trhp_posfb.free.ac.txt hout
quit
.endc
.end
