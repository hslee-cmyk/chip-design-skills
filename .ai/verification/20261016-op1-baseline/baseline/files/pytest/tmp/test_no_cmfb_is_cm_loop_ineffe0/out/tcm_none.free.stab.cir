* spice_oracle: tcm_none bias=free
.include "C:/pdk/sky130_fd_pr/cells/nfet_01v8/sky130_fd_pr__nfet_01v8__tt.pm3.spice"
.include "C:/pdk/sky130_fd_pr/cells/nfet_01v8/sky130_fd_pr__nfet_01v8__mismatch.corner.spice"
.temp 27
.option gmin=1e-15 reltol=1e-4 abstol=1e-14 vntol=1e-7
Vrail_vdd vdd 0 DC 1.8
XM1 op ip 0 0 sky130_fd_pr__nfet_01v8 l=5e-07 w=2e-06 m=2 ad=0 as=0 pd=0 ps=0
XM2 om im 0 0 sky130_fd_pr__nfet_01v8 l=5e-07 w=2e-06 m=2 ad=0 as=0 pd=0 ps=0
Cp_CL1 op 0 1e-11
Cp_CL2 om 0 1e-11
Rp_RL1 vdd op 200000
Rp_RL2 vdd om 200000
Ecl_ip ip ecl_ip op om 0.5
Vcl_ip ecl_ip 0 PULSE(0.6 0.6129324629 3.420316267e-07 3.420316267e-07 3.420316267e-07 3.420316267e-07 2.852483011e-05)
Ecl_im im ecl_im op om -0.5
Vcl_im ecl_im 0 PULSE(0.6 0.5870675371 3.420316267e-07 3.420316267e-07 3.420316267e-07 3.420316267e-07 2.852483011e-05)
.save v(ip) v(im)
.control
set noaskquit
set numdgt=8
set wr_singlescale
let sw_tke = 1.368126507e-06
let sw_w = 2.149048092e-06
let sw_k = 6
let sw_rt = 0.0001
let sw_fl0 = 0.0001202
let sw_u = 5e-09
let sw_j = 0
let sw_m1 = 0
let sw_p1 = 0
let sw_p2 = 0
let sw_fin = 0
let sw_kind = 0
stop when time > 3.517174599e-06
tran 9.477529326e-09 1.426241506e-05 0 9.477529326e-09
while sw_fin = 0
  let sw_j = sw_j + 1
  let hst = v(ip) - v(im)
  let sw_lo = sw_tke + (sw_j - 1) * sw_w
  let sw_hi = sw_tke + sw_j * sw_w
  let sw_tl = time[length(time) - 1]
  if sw_tl >= sw_hi * (1 - 2 * sw_u)
    let sw_m = maximum(abs(hst - (hst[0])) * (time >= sw_lo) * (time <= sw_hi))
    echo STABWIN $&sw_j $&sw_m
    if sw_j = 1
      let sw_m1 = sw_m
    end
    let sw_fl = sw_fl0 + sw_u * maximum(abs(hst))
    let sw_up = (sw_m * (1 - sw_rt) >= sw_p1 * (1 + sw_rt) + sw_fl)
    let sw_dn = (sw_p1 * (1 - sw_rt) >= sw_m * (1 + sw_rt) + sw_fl)
    let sw_up0 = (sw_p1 * (1 - sw_rt) >= sw_p2 * (1 + sw_rt) + sw_fl)
    let sw_dn0 = (sw_p2 * (1 - sw_rt) >= sw_p1 * (1 + sw_rt) + sw_fl)
    let sw_upf = (sw_m * (1 - sw_rt) >= sw_m1 * (1 + sw_rt) + sw_fl)
    let sw_ab1 = (sw_m * (1 - sw_rt) >= sw_fl)
    let sw_ab0 = (sw_p1 * (1 - sw_rt) >= sw_fl)
    let sw_fl1 = sw_ab1 * (1 - sw_dn)
    let sw_fl0f = sw_ab0 * (1 - sw_dn0)
    let sw_gr = sw_up0 * sw_up * sw_upf
    let sw_lc = sw_fl0f * sw_fl1
    if sw_j >= 3
      if sw_gr >= 1
        let sw_fin = 1
        let sw_kind = 1
      end
      if sw_lc >= 1
        let sw_fin = 1
        let sw_kind = 2
      end
    end
    if sw_fin = 0
      if sw_j >= sw_k
        let sw_fin = 2
      else
        let sw_p2 = sw_p1
        let sw_p1 = sw_m
        let sw_nb = sw_tke + (sw_j + 1) * sw_w
        delete all
        if sw_k >= sw_j + 2
          stop when time > $&sw_nb
        end
        resume
      end
    end
  else
    let sw_fin = 3
  end
end
echo STABEND $&sw_j $&sw_fin $&sw_kind
let hst = v(ip) - v(im)
wrdata tcm_none.free.stab.txt hst
quit
.endc
.end
