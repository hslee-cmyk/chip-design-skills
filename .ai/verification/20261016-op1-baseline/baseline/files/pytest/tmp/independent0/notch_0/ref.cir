* independent reference
.include "C:/pdk/sky130_fd_pr/cells/nfet_01v8/sky130_fd_pr__nfet_01v8__tt.pm3.spice"
.include "C:/pdk/sky130_fd_pr/cells/nfet_01v8/sky130_fd_pr__nfet_01v8__mismatch.corner.spice"
.include "C:/pdk/sky130_fd_pr/models/parameters/lod.spice"
.include "C:/pdk/sky130_fd_pr/cells/pfet_01v8/sky130_fd_pr__pfet_01v8__tt.pm3.spice"
.include "C:/pdk/sky130_fd_pr/cells/pfet_01v8/sky130_fd_pr__pfet_01v8__mismatch.corner.spice"
.temp 27.0
.option gmin=1e-15 reltol=1e-4 abstol=1e-14 vntol=1e-7
Vdd vdd 0 DC 1.8
Vin nin 0 DC 0.7 AC 1
RL vdd n1 129409.146
Rt1 n1 nm 10000000.0
Rt2 nm no 10000000.0
Ctm nm 0 3.2e-12
Ct1 n1 nc 1.6e-12
Ct2 nc no 1.6e-12
Rts nc 0 5000000.0
XM1_0 n1 nin 0 0 sky130_fd_pr__nfet_01v8 l=5e-07 w=2e-06
XM1_1 n1 nin 0 0 sky130_fd_pr__nfet_01v8 l=5e-07 w=2e-06
.control
set noaskquit
op
print v(no)
print v(nin)
ac dec 40 0.01 10000000000.0
let hr = real(v(no))
let hi = imag(v(no))
set wr_singlescale
wrdata ref_ac.txt hr hi
quit
.endc
.end
