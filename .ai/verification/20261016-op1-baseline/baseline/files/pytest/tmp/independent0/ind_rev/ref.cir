* independent reference
.include "C:/pdk/sky130_fd_pr/cells/nfet_01v8/sky130_fd_pr__nfet_01v8__tt.pm3.spice"
.include "C:/pdk/sky130_fd_pr/cells/nfet_01v8/sky130_fd_pr__nfet_01v8__mismatch.corner.spice"
.include "C:/pdk/sky130_fd_pr/models/parameters/lod.spice"
.include "C:/pdk/sky130_fd_pr/cells/pfet_01v8/sky130_fd_pr__pfet_01v8__tt.pm3.spice"
.include "C:/pdk/sky130_fd_pr/cells/pfet_01v8/sky130_fd_pr__pfet_01v8__mismatch.corner.spice"
.temp 27.0
.option gmin=1e-15 reltol=1e-4 abstol=1e-14 vntol=1e-7
Vdd vdd 0 DC 1.8
Vsp vsp 0 DC 1.5
Vpb pb 0 DC 0.3
RP pout 0 10000.0
Vsd md 0 DC 0
XM2 md vdd pout 0 sky130_fd_pr__nfet_01v8 l=0.5e-6 w=2e-6
XMP1_0 pout pb vsp vdd sky130_fd_pr__pfet_01v8 l=5e-07 w=2e-06
XMP1_1 pout pb vsp vdd sky130_fd_pr__pfet_01v8 l=5e-07 w=2e-06
XMP1_2 pout pb vsp vdd sky130_fd_pr__pfet_01v8 l=5e-07 w=2e-06
.control
set noaskquit
op
print i(vsd)
print @m.xm2.msky130_fd_pr__nfet_01v8[id]
quit
.endc
.end
