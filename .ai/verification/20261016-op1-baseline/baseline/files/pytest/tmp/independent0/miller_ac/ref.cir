* independent reference
.include "C:/pdk/sky130_fd_pr/cells/nfet_01v8/sky130_fd_pr__nfet_01v8__tt.pm3.spice"
.include "C:/pdk/sky130_fd_pr/cells/nfet_01v8/sky130_fd_pr__nfet_01v8__mismatch.corner.spice"
.include "C:/pdk/sky130_fd_pr/models/parameters/lod.spice"
.include "C:/pdk/sky130_fd_pr/cells/pfet_01v8/sky130_fd_pr__pfet_01v8__tt.pm3.spice"
.include "C:/pdk/sky130_fd_pr/cells/pfet_01v8/sky130_fd_pr__pfet_01v8__mismatch.corner.spice"
.temp 27.0
.option gmin=1e-15 reltol=1e-4 abstol=1e-14 vntol=1e-7
Vdd vdd 0 DC 1.8
Vin nin 0 DC 0.7 AC 1
R1 vdd n1 129409.17652235192
XM1_0 n1 nin 0 0 sky130_fd_pr__nfet_01v8 l=5e-07 w=2e-06
XM1_1 n1 nin 0 0 sky130_fd_pr__nfet_01v8 l=5e-07 w=2e-06
R2 vdd n2 64704.740504579335
XM2_0 n2 n1 0 0 sky130_fd_pr__nfet_01v8 l=5e-07 w=2e-06
XM2_1 n2 n1 0 0 sky130_fd_pr__nfet_01v8 l=5e-07 w=2e-06
XM2_2 n2 n1 0 0 sky130_fd_pr__nfet_01v8 l=5e-07 w=2e-06
XM2_3 n2 n1 0 0 sky130_fd_pr__nfet_01v8 l=5e-07 w=2e-06
Cc n1 n2 3e-12
CL n2 0 2e-12
.control
set noaskquit
op
print v(n1)
print v(n2)
ac dec 40 0.01 10000000000.0
let hr = real(v(n2))
let hi = imag(v(n2))
set wr_singlescale
wrdata ref_ac.txt hr hi
quit
.endc
.end
