* independent rout run
.include "C:/pdk/sky130_fd_pr/cells/nfet_01v8/sky130_fd_pr__nfet_01v8__tt.pm3.spice"
.include "C:/pdk/sky130_fd_pr/cells/nfet_01v8/sky130_fd_pr__nfet_01v8__mismatch.corner.spice"
.include "C:/pdk/sky130_fd_pr/models/parameters/lod.spice"
.include "C:/pdk/sky130_fd_pr/cells/pfet_01v8/sky130_fd_pr__pfet_01v8__tt.pm3.spice"
.include "C:/pdk/sky130_fd_pr/cells/pfet_01v8/sky130_fd_pr__pfet_01v8__mismatch.corner.spice"
.temp 27.0
.option gmin=1e-15 reltol=1e-4 abstol=1e-14 vntol=1e-7
Vdd vdd 0 DC 1.8 AC 0
Vsp vsp 0 DC 1.5 AC 0
Vin nin 0 DC 0.7 AC 0
Vpb pb 0 DC 0.3 AC 0
RL vdd nout 100000.0
CL nout 0 1e-12
RP pout 0 10000.0
XM1_0 nout nin 0 0 sky130_fd_pr__nfet_01v8 l=5e-07 w=2e-06
XM1_1 nout nin 0 0 sky130_fd_pr__nfet_01v8 l=5e-07 w=2e-06
XMP1_0 pout pb vsp vdd sky130_fd_pr__pfet_01v8 l=5e-07 w=2e-06
XMP1_1 pout pb vsp vdd sky130_fd_pr__pfet_01v8 l=5e-07 w=2e-06
XMP1_2 pout pb vsp vdd sky130_fd_pr__pfet_01v8 l=5e-07 w=2e-06
Iinj 0 nout DC 0 AC 1
Iinjn pout 0 DC 0 AC 1
.control
set noaskquit
op
ac lin 1 0.01 0.01
let h = v(nout)-v(pout)
let hr = real(h)
let hi = imag(h)
set wr_singlescale
wrdata h.txt hr hi
quit
.endc
.end
