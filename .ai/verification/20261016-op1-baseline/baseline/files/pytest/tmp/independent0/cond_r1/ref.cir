* independent reference
.include "C:/pdk/sky130_fd_pr/cells/nfet_01v8/sky130_fd_pr__nfet_01v8__tt.pm3.spice"
.include "C:/pdk/sky130_fd_pr/cells/nfet_01v8/sky130_fd_pr__nfet_01v8__mismatch.corner.spice"
.include "C:/pdk/sky130_fd_pr/models/parameters/lod.spice"
.include "C:/pdk/sky130_fd_pr/cells/pfet_01v8/sky130_fd_pr__pfet_01v8__tt.pm3.spice"
.include "C:/pdk/sky130_fd_pr/cells/pfet_01v8/sky130_fd_pr__pfet_01v8__mismatch.corner.spice"
.temp 27.0
.option gmin=1e-15 reltol=1e-4 abstol=1e-14 vntol=1e-7
Vn1 n1 0 DC 0.7
Vg g 0 DC 0.7
XM1_0 n1 g 0 0 sky130_fd_pr__nfet_01v8 l=5e-07 w=2e-06
XM1_1 n1 g 0 0 sky130_fd_pr__nfet_01v8 l=5e-07 w=2e-06
XM1_2 n1 g 0 0 sky130_fd_pr__nfet_01v8 l=5e-07 w=2e-06
XM1_3 n1 g 0 0 sky130_fd_pr__nfet_01v8 l=5e-07 w=2e-06
XM1_4 n1 g 0 0 sky130_fd_pr__nfet_01v8 l=5e-07 w=2e-06
XM1_5 n1 g 0 0 sky130_fd_pr__nfet_01v8 l=5e-07 w=2e-06
XM1_6 n1 g 0 0 sky130_fd_pr__nfet_01v8 l=5e-07 w=2e-06
XM1_7 n1 g 0 0 sky130_fd_pr__nfet_01v8 l=5e-07 w=2e-06
XM1_8 n1 g 0 0 sky130_fd_pr__nfet_01v8 l=5e-07 w=2e-06
XM1_9 n1 g 0 0 sky130_fd_pr__nfet_01v8 l=5e-07 w=2e-06
XM1_10 n1 g 0 0 sky130_fd_pr__nfet_01v8 l=5e-07 w=2e-06
XM1_11 n1 g 0 0 sky130_fd_pr__nfet_01v8 l=5e-07 w=2e-06
XM1_12 n1 g 0 0 sky130_fd_pr__nfet_01v8 l=5e-07 w=2e-06
XM1_13 n1 g 0 0 sky130_fd_pr__nfet_01v8 l=5e-07 w=2e-06
XM1_14 n1 g 0 0 sky130_fd_pr__nfet_01v8 l=5e-07 w=2e-06
XM1_15 n1 g 0 0 sky130_fd_pr__nfet_01v8 l=5e-07 w=2e-06
XM3_0 n1 g 0 0 sky130_fd_pr__nfet_01v8 l=5e-07 w=2e-06
.control
set noaskquit
op
print i(vn1)
quit
.endc
.end
