* independent C10 reference
.include "C:/pdk/sky130_fd_pr/cells/nfet_01v8/sky130_fd_pr__nfet_01v8__tt.pm3.spice"
.include "C:/pdk/sky130_fd_pr/cells/nfet_01v8/sky130_fd_pr__nfet_01v8__mismatch.corner.spice"
.include "C:/pdk/sky130_fd_pr/models/parameters/lod.spice"
.include "C:/pdk/sky130_fd_pr/cells/pfet_01v8/sky130_fd_pr__pfet_01v8__tt.pm3.spice"
.include "C:/pdk/sky130_fd_pr/cells/pfet_01v8/sky130_fd_pr__pfet_01v8__mismatch.corner.spice"
.temp 27.0
.option gmin=1e-15 reltol=1e-4 abstol=1e-14 vntol=1e-7
Vdd vdd 0 DC 1.8
Vb vb 0 DC 0.7
Vin nin 0 DC 0.7
R1 vdd n1 51764.70588
R2 vdd n2 129400.0
Rb vb n3 1000000.0
Cc n2 n3 1e-12
XM1_0 n1 nin 0 0 sky130_fd_pr__nfet_01v8 l=5e-07 w=2e-06
XM2_0 n2 n1 0 0 sky130_fd_pr__nfet_01v8 l=5e-07 w=2e-06
XM2_1 n2 n1 0 0 sky130_fd_pr__nfet_01v8 l=5e-07 w=2e-06
XM3_0 n1 n3 0 0 sky130_fd_pr__nfet_01v8 l=5e-07 w=2e-06
XM3_1 n1 n3 0 0 sky130_fd_pr__nfet_01v8 l=5e-07 w=2e-06
XM3_2 n1 n3 0 0 sky130_fd_pr__nfet_01v8 l=5e-07 w=2e-06
XM3_3 n1 n3 0 0 sky130_fd_pr__nfet_01v8 l=5e-07 w=2e-06
Ik 0 n3 DC 0 PULSE(0 1e-12 5e-10 1e-11 1e-11 1e-10)
.control
set noaskquit
tran 1e-11 2e-8 0 1e-11
let vo2 = v(n2)
set wr_singlescale
wrdata g.txt vo2
quit
.endc
.end
