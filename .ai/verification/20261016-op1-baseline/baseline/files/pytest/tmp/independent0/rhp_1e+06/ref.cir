* independent reference
.include "C:/pdk/sky130_fd_pr/cells/nfet_01v8/sky130_fd_pr__nfet_01v8__tt.pm3.spice"
.include "C:/pdk/sky130_fd_pr/cells/nfet_01v8/sky130_fd_pr__nfet_01v8__mismatch.corner.spice"
.include "C:/pdk/sky130_fd_pr/models/parameters/lod.spice"
.include "C:/pdk/sky130_fd_pr/cells/pfet_01v8/sky130_fd_pr__pfet_01v8__tt.pm3.spice"
.include "C:/pdk/sky130_fd_pr/cells/pfet_01v8/sky130_fd_pr__pfet_01v8__mismatch.corner.spice"
.temp 27.0
.option gmin=1e-15 reltol=1e-4 abstol=1e-14 vntol=1e-7
Vdd vdd 0 DC 1.8
Vb vb 0 DC 0.7
Vin nin 0 DC 0.7 AC 1
R1 vdd n1 51764.70588
R2 vdd n2 129400.0
Rb vb n3 1000000.0
Cc n2 n3 1e-12
XM1_0 n1 nin 0 0 sky130_fd_pr__nfet_01v8 l=5e-07 w=2e-06
XM2_0 n2 n1 0 0 sky130_fd_pr__nfet_01v8 l=5e-07 w=2e-06
XM2_1 n2 n1 0 0 sky130_fd_pr__nfet_01v8 l=5e-07 w=2e-06
XM3_0 n1 n3 0 0 sky130_fd_pr__nfet_01v8 l=5e-07 w=2e-06
XM3_1 n1 n3 0 0 sky130_fd_pr__nfet_01v8 l=5e-07 w=2e-06
XM3_2 n1 n3 0 0 sky130_fd_pr__nfet_01v8 l=5e-07 w=2e-06
XM3_3 n1 n3 0 0 sky130_fd_pr__nfet_01v8 l=5e-07 w=2e-06
.control
set noaskquit
op
print v(nin)
print v(n1)
print v(n2)
print v(n3)
print @m.xm1_0.msky130_fd_pr__nfet_01v8[gm]
print @m.xm1_0.msky130_fd_pr__nfet_01v8[gds]
print @m.xm1_0.msky130_fd_pr__nfet_01v8[vds]
print @m.xm1_0.msky130_fd_pr__nfet_01v8[vdsat]
print @m.xm2_0.msky130_fd_pr__nfet_01v8[gm]
print @m.xm2_0.msky130_fd_pr__nfet_01v8[gds]
print @m.xm2_0.msky130_fd_pr__nfet_01v8[vds]
print @m.xm2_0.msky130_fd_pr__nfet_01v8[vdsat]
print @m.xm2_1.msky130_fd_pr__nfet_01v8[gm]
print @m.xm2_1.msky130_fd_pr__nfet_01v8[gds]
print @m.xm2_1.msky130_fd_pr__nfet_01v8[vds]
print @m.xm2_1.msky130_fd_pr__nfet_01v8[vdsat]
print @m.xm3_0.msky130_fd_pr__nfet_01v8[gm]
print @m.xm3_0.msky130_fd_pr__nfet_01v8[gds]
print @m.xm3_0.msky130_fd_pr__nfet_01v8[vds]
print @m.xm3_0.msky130_fd_pr__nfet_01v8[vdsat]
print @m.xm3_1.msky130_fd_pr__nfet_01v8[gm]
print @m.xm3_1.msky130_fd_pr__nfet_01v8[gds]
print @m.xm3_1.msky130_fd_pr__nfet_01v8[vds]
print @m.xm3_1.msky130_fd_pr__nfet_01v8[vdsat]
print @m.xm3_2.msky130_fd_pr__nfet_01v8[gm]
print @m.xm3_2.msky130_fd_pr__nfet_01v8[gds]
print @m.xm3_2.msky130_fd_pr__nfet_01v8[vds]
print @m.xm3_2.msky130_fd_pr__nfet_01v8[vdsat]
print @m.xm3_3.msky130_fd_pr__nfet_01v8[gm]
print @m.xm3_3.msky130_fd_pr__nfet_01v8[gds]
print @m.xm3_3.msky130_fd_pr__nfet_01v8[vds]
print @m.xm3_3.msky130_fd_pr__nfet_01v8[vdsat]
ac dec 40 0.01 10000000000.0
let hr = real(v(n2))
let hi = imag(v(n2))
set wr_singlescale
wrdata ref_ac.txt hr hi
quit
.endc
.end
