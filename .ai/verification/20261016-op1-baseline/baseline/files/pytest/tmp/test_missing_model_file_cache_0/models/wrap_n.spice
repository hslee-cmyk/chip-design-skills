.include "C:/Users/HSLEE/Documents/Todoc/fpga/wt/_scratch_op1/baseline/pytest/tmp/test_missing_model_file_cache_0/models/sky130_fd_pr__nfet_01v8__tt.pm3.spice"
.include "C:/Users/HSLEE/Documents/Todoc/fpga/wt/_scratch_op1/baseline/pytest/tmp/test_missing_model_file_cache_0/nope.spice"
