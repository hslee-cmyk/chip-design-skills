* spice_oracle: tcs_nmos_rload bias=free
.include "C:/pdk/sky130_fd_pr/cells/nfet_01v8/sky130_fd_pr__nfet_01v8__tt.pm3.spice"
.include "C:/pdk/sky130_fd_pr/cells/nfet_01v8/sky130_fd_pr__nfet_01v8__mismatch.corner.spice"
.include "C:/pdk/sky130_fd_pr/models/parameters/lod.spice"
.include "C:/pdk/sky130_fd_pr/cells/pfet_01v8/sky130_fd_pr__pfet_01v8__tt.pm3.spice"
.include "C:/pdk/sky130_fd_pr/cells/pfet_01v8/sky130_fd_pr__pfet_01v8__mismatch.corner.spice"
.temp 27
.option gmin=1e-15 reltol=1e-4 abstol=1e-14 vntol=1e-7
Vrail_vdd vdd 0 DC 1.8
Vrail_vsp vsp 0 DC 1.5
XM1 nout nin 0 0 sky130_fd_pr__nfet_01v8 l=5e-07 w=2e-06 m=2 ad=0 as=0 pd=0 ps=0
XMP1 pout pb vsp vdd sky130_fd_pr__pfet_01v8 l=5e-07 w=2e-06 m=3 ad=0 as=0 pd=0 ps=0
XMX1 na nb 0 0 sky130_fd_pr__nfet_01v8 l=5e-07 w=2e-06 m=2 ad=0 as=0 pd=0 ps=0
XMX2 nb na 0 0 sky130_fd_pr__nfet_01v8 l=5e-07 w=2e-06 m=2 ad=0 as=0 pd=0 ps=0
Rp_RL vdd nout 100000
Cp_CL nout 0 1e-12
Rp_RP pout 0 10000
Rp_RXa vdd na 100000
Rp_RXb vdd nb 100000
Vdc_nin dcs_nin 0 DC 0.7
Ldc_nin dcs_nin nin 1e+12
Cac_nin nin acs_nin 1
Vac_nin acs_nin 0 DC 0 AC 1
Vbias_pb pb 0 DC 0.3
Irout_0 0 pout DC 0 AC 0
Irout_1 0 nout DC 0 AC 0
Irout_2 0 nout DC 0 AC 0
Irout_2n pout 0 DC 0 AC 0
Irout_3 0 na DC 0 AC 0
Irout_3n nb 0 DC 0 AC 0
.control
set noaskquit
op
echo OPSTART
print @m.xm1.msky130_fd_pr__nfet_01v8[id]
print @m.xm1.msky130_fd_pr__nfet_01v8[gm]
print @m.xm1.msky130_fd_pr__nfet_01v8[gds]
print @m.xm1.msky130_fd_pr__nfet_01v8[vth]
print @m.xm1.msky130_fd_pr__nfet_01v8[vdsat]
print @m.xm1.msky130_fd_pr__nfet_01v8[vgs]
print @m.xm1.msky130_fd_pr__nfet_01v8[vds]
print @m.xm1.msky130_fd_pr__nfet_01v8[vbs]
print @m.xmp1.msky130_fd_pr__pfet_01v8[id]
print @m.xmp1.msky130_fd_pr__pfet_01v8[gm]
print @m.xmp1.msky130_fd_pr__pfet_01v8[gds]
print @m.xmp1.msky130_fd_pr__pfet_01v8[vth]
print @m.xmp1.msky130_fd_pr__pfet_01v8[vdsat]
print @m.xmp1.msky130_fd_pr__pfet_01v8[vgs]
print @m.xmp1.msky130_fd_pr__pfet_01v8[vds]
print @m.xmp1.msky130_fd_pr__pfet_01v8[vbs]
print @m.xmx1.msky130_fd_pr__nfet_01v8[id]
print @m.xmx1.msky130_fd_pr__nfet_01v8[gm]
print @m.xmx1.msky130_fd_pr__nfet_01v8[gds]
print @m.xmx1.msky130_fd_pr__nfet_01v8[vth]
print @m.xmx1.msky130_fd_pr__nfet_01v8[vdsat]
print @m.xmx1.msky130_fd_pr__nfet_01v8[vgs]
print @m.xmx1.msky130_fd_pr__nfet_01v8[vds]
print @m.xmx1.msky130_fd_pr__nfet_01v8[vbs]
print @m.xmx2.msky130_fd_pr__nfet_01v8[id]
print @m.xmx2.msky130_fd_pr__nfet_01v8[gm]
print @m.xmx2.msky130_fd_pr__nfet_01v8[gds]
print @m.xmx2.msky130_fd_pr__nfet_01v8[vth]
print @m.xmx2.msky130_fd_pr__nfet_01v8[vdsat]
print @m.xmx2.msky130_fd_pr__nfet_01v8[vgs]
print @m.xmx2.msky130_fd_pr__nfet_01v8[vds]
print @m.xmx2.msky130_fd_pr__nfet_01v8[vbs]
print v(nout)
print v(nin)
print v(pout)
print v(pb)
print v(vsp)
print v(vdd)
print v(na)
print v(nb)
print i(vrail_vdd)
print i(vrail_vsp)
echo OPEND
ac dec 40 0.01 1e+10
let hout = v(nout)
set wr_singlescale
wrdata tcs_nmos_rload.free.ac.txt hout
set wr_singlescale
alter @vac_nin[acmag] = 0
alter @vbias_pb[acmag] = 0
alter @vrail_vdd[acmag] = 0
alter @vrail_vsp[acmag] = 0
alter @irout_0[acmag] = 1
alter @irout_1[acmag] = 0
alter @irout_2[acmag] = 0
alter @irout_2n[acmag] = 0
alter @irout_3[acmag] = 0
alter @irout_3n[acmag] = 0
ac lin 1 0.01 0.01
let hrout0 = v(pout)
wrdata tcs_nmos_rload.free.rout0.txt hrout0
alter @vac_nin[acmag] = 0
alter @vbias_pb[acmag] = 0
alter @vrail_vdd[acmag] = 0
alter @vrail_vsp[acmag] = 0
alter @irout_0[acmag] = 0
alter @irout_1[acmag] = 1
alter @irout_2[acmag] = 0
alter @irout_2n[acmag] = 0
alter @irout_3[acmag] = 0
alter @irout_3n[acmag] = 0
ac lin 1 0.01 0.01
let hrout1 = v(nout)
wrdata tcs_nmos_rload.free.rout1.txt hrout1
alter @vac_nin[acmag] = 0
alter @vbias_pb[acmag] = 0
alter @vrail_vdd[acmag] = 0
alter @vrail_vsp[acmag] = 0
alter @irout_0[acmag] = 0
alter @irout_1[acmag] = 0
alter @irout_2[acmag] = 1
alter @irout_2n[acmag] = 1
alter @irout_3[acmag] = 0
alter @irout_3n[acmag] = 0
ac lin 1 0.01 0.01
let hrout2 = v(nout) - v(pout)
wrdata tcs_nmos_rload.free.rout2.txt hrout2
alter @vac_nin[acmag] = 0
alter @vbias_pb[acmag] = 0
alter @vrail_vdd[acmag] = 0
alter @vrail_vsp[acmag] = 0
alter @irout_0[acmag] = 0
alter @irout_1[acmag] = 0
alter @irout_2[acmag] = 0
alter @irout_2n[acmag] = 0
alter @irout_3[acmag] = 1
alter @irout_3n[acmag] = 1
ac lin 1 0.01 0.01
let hrout3 = v(na) - v(nb)
wrdata tcs_nmos_rload.free.rout3.txt hrout3
quit
.endc
.end
