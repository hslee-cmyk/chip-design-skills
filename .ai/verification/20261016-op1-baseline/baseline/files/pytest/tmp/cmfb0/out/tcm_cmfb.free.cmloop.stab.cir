* spice_oracle: tcm_cmfb bias=free
.include "C:/pdk/sky130_fd_pr/cells/nfet_01v8/sky130_fd_pr__nfet_01v8__tt.pm3.spice"
.include "C:/pdk/sky130_fd_pr/cells/nfet_01v8/sky130_fd_pr__nfet_01v8__mismatch.corner.spice"
.include "C:/pdk/sky130_fd_pr/models/parameters/lod.spice"
.include "C:/pdk/sky130_fd_pr/cells/pfet_01v8/sky130_fd_pr__pfet_01v8__tt.pm3.spice"
.include "C:/pdk/sky130_fd_pr/cells/pfet_01v8/sky130_fd_pr__pfet_01v8__mismatch.corner.spice"
.temp 27
.option gmin=1e-15 reltol=1e-4 abstol=1e-14 vntol=1e-7
Vrail_vdd vdd 0 DC 1.8
XM1 lbx_op ip 0 0 sky130_fd_pr__nfet_01v8 l=5e-07 w=2e-06 m=2 ad=0 as=0 pd=0 ps=0
XM2 lbx_om im 0 0 sky130_fd_pr__nfet_01v8 l=5e-07 w=2e-06 m=2 ad=0 as=0 pd=0 ps=0
XM3 lbx_op c vdd vdd sky130_fd_pr__pfet_01v8 l=5e-07 w=2e-06 m=2 ad=0 as=0 pd=0 ps=0
XM4 lbx_om c vdd vdd sky130_fd_pr__pfet_01v8 l=5e-07 w=2e-06 m=2 ad=0 as=0 pd=0 ps=0
Cp_CL1 op 0 1e-11
Cp_CL2 om 0 1e-11
Rp_R1 op c 1000000
Rp_R2 c om 1000000
Cp_Cg c 0 5e-12
Efb_ip fbs_ip 0 om op 0.5
Vofs_ip fbs_ip fbd_ip DC -0.6
Itb_Lfb_ip fbd_ip ip DC 0
Cac_ip ip acs_ip 1
Vac_ip acs_ip 0 DC 0 AC 0
Efb_im fbs_im 0 op om 0.5
Vofs_im fbs_im fbd_im DC -0.6
Itb_Lfb_im fbd_im im DC 0
Cac_im im acs_im 1
Vac_im acs_im 0 DC 0 AC 0
Vlb_op op lbx_op DC 0 PULSE(0 0.01293246289 1.192075562e-06 1.192075562e-06 1.192075562e-06 1.192075562e-06 9.941698436e-05)
Ilb_op 0 op DC 0 AC 0
Vlb_om om lbx_om DC 0 PULSE(0 0.01293246289 1.192075562e-06 1.192075562e-06 1.192075562e-06 1.192075562e-06 9.941698436e-05)
Ilb_om 0 om DC 0 AC 0
.ic v(ip)=0.6
.ic v(im)=0.6
.save v(op) v(om)
.control
set noaskquit
set numdgt=8
set wr_singlescale
let sw_tke = 4.768302248e-06
let sw_w = 7.490031656e-06
let sw_k = 6
let sw_rt = 0.0001
let sw_fl0 = 0.0001671794
let sw_u = 5e-09
let sw_j = 0
let sw_m1 = 0
let sw_p1 = 0
let sw_p2 = 0
let sw_fin = 0
let sw_kind = 0
stop when time > 1.22583339e-05
tran 3.174644783e-08 4.970849218e-05 0 3.174644783e-08
while sw_fin = 0
  let sw_j = sw_j + 1
  let hst = v(op) + v(om)
  let sw_lo = sw_tke + (sw_j - 1) * sw_w
  let sw_hi = sw_tke + sw_j * sw_w
  let sw_tl = time[length(time) - 1]
  if sw_tl >= sw_hi * (1 - 2 * sw_u)
    let sw_m = maximum(abs(hst - (hst[0])) * (time >= sw_lo) * (time <= sw_hi))
    echo STABWIN $&sw_j $&sw_m
    if sw_j = 1
      let sw_m1 = sw_m
    end
    let sw_fl = sw_fl0 + sw_u * maximum(abs(hst))
    let sw_up = (sw_m * (1 - sw_rt) >= sw_p1 * (1 + sw_rt) + sw_fl)
    let sw_dn = (sw_p1 * (1 - sw_rt) >= sw_m * (1 + sw_rt) + sw_fl)
    let sw_up0 = (sw_p1 * (1 - sw_rt) >= sw_p2 * (1 + sw_rt) + sw_fl)
    let sw_dn0 = (sw_p2 * (1 - sw_rt) >= sw_p1 * (1 + sw_rt) + sw_fl)
    let sw_upf = (sw_m * (1 - sw_rt) >= sw_m1 * (1 + sw_rt) + sw_fl)
    let sw_ab1 = (sw_m * (1 - sw_rt) >= sw_fl)
    let sw_ab0 = (sw_p1 * (1 - sw_rt) >= sw_fl)
    let sw_fl1 = sw_ab1 * (1 - sw_dn)
    let sw_fl0f = sw_ab0 * (1 - sw_dn0)
    let sw_gr = sw_up0 * sw_up * sw_upf
    let sw_lc = sw_fl0f * sw_fl1
    if sw_j >= 3
      if sw_gr >= 1
        let sw_fin = 1
        let sw_kind = 1
      end
      if sw_lc >= 1
        let sw_fin = 1
        let sw_kind = 2
      end
    end
    if sw_fin = 0
      if sw_j >= sw_k
        let sw_fin = 2
      else
        let sw_p2 = sw_p1
        let sw_p1 = sw_m
        let sw_nb = sw_tke + (sw_j + 1) * sw_w
        delete all
        if sw_k >= sw_j + 2
          stop when time > $&sw_nb
        end
        resume
      end
    end
  else
    let sw_fin = 3
  end
end
echo STABEND $&sw_j $&sw_fin $&sw_kind
let hst = v(op) + v(om)
wrdata tcm_cmfb.free.cmloop.stab.txt hst
quit
.endc
.end
