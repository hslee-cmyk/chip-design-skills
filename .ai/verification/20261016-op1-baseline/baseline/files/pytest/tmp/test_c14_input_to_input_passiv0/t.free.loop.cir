* spice_oracle: tdiff_fb bias=free
.include "C:/pdk/sky130_fd_pr/cells/nfet_01v8/sky130_fd_pr__nfet_01v8__tt.pm3.spice"
.include "C:/pdk/sky130_fd_pr/cells/nfet_01v8/sky130_fd_pr__nfet_01v8__mismatch.corner.spice"
.temp 27
.option gmin=1e-15 reltol=1e-4 abstol=1e-14 vntol=1e-7
Vrail_vdd vdd 0 DC 1.8
XMp op nip 0 0 sky130_fd_pr__nfet_01v8 l=5e-07 w=2e-06 m=2 ad=0 as=0 pd=0 ps=0
XMn on nin 0 0 sky130_fd_pr__nfet_01v8 l=5e-07 w=2e-06 m=2 ad=0 as=0 pd=0 ps=0
Rp_RLp vdd op 100000
Cp_CLp op 0 1e-11
Rp_Rfp op lbx_nip 1000000
Cp_Cinp lbx_nip 0 1e-11
Rp_RLn vdd on 100000
Cp_CLn on 0 1e-11
Rp_Rfn on lbx_nin 1000000
Cp_Cinn lbx_nin 0 1e-11
Cp_Cpn nip nin 1e-12
Efb_nip fbs_nip 0 on op 0.5
Vofs_nip fbs_nip fbd_nip DC -0.7
Lfb_nip fbd_nip nip 1e+20
Vlb_nip nip lbx_nip DC 0 AC 0.5
Ilb_nip 0 nip DC 0 AC 0
Efb_nin fbs_nin 0 op on 0.5
Vofs_nin fbs_nin fbd_nin DC -0.7
Lfb_nin fbd_nin nin 1e+20
Vlb_nin nin lbx_nin DC 0 AC -0.5
Ilb_nin 0 nin DC 0 AC 0
.control
set noaskquit
set wr_singlescale
ac dec 40 0.01 1e+10
wrdata t.free.loop.v.txt v(lbx_nip) v(nip) v(lbx_nin) v(nin)
alter @vlb_nip[acmag] = 0
alter @ilb_nip[acmag] = 0.5
alter @vlb_nin[acmag] = 0
alter @ilb_nin[acmag] = -0.5
ac dec 40 0.01 1e+10
wrdata t.free.loop.i.txt i(vlb_nip) i(vlb_nin) v(nip) v(nin)
quit
.endc
.end
