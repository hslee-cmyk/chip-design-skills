* u6 toy 5T
.include "C:/pdk/sky130_fd_pr/cells/nfet_01v8/sky130_fd_pr__nfet_01v8__tt.pm3.spice"
.include "C:/pdk/sky130_fd_pr/cells/nfet_01v8/sky130_fd_pr__nfet_01v8__mismatch.corner.spice"
.include "C:/pdk/sky130_fd_pr/models/parameters/lod.spice"
.include "C:/pdk/sky130_fd_pr/cells/pfet_01v8/sky130_fd_pr__pfet_01v8__tt.pm3.spice"
.include "C:/pdk/sky130_fd_pr/cells/pfet_01v8/sky130_fd_pr__pfet_01v8__mismatch.corner.spice"
.temp 27.0
.option gmin=1e-15 reltol=1e-4 abstol=1e-14 vntol=1e-7
Vdd vdd 0 DC 1.8
Vinp inp 0 DC 0.9
IT tail 0 DC 2e-05
CL out 0 1e-12
Esv inn 0 vref out 1e6
Vref vref 0 DC 0.8999991
XM1_0 d1 inp tail 0 sky130_fd_pr__nfet_01v8 l=1e-06 w=2e-06
XM1_1 d1 inp tail 0 sky130_fd_pr__nfet_01v8 l=1e-06 w=2e-06
XM2_0 out inn tail 0 sky130_fd_pr__nfet_01v8 l=1e-06 w=2e-06
XM2_1 out inn tail 0 sky130_fd_pr__nfet_01v8 l=1e-06 w=2e-06
XM3_0 d1 d1 vdd vdd sky130_fd_pr__pfet_01v8 l=1e-06 w=2e-06
XM3_1 d1 d1 vdd vdd sky130_fd_pr__pfet_01v8 l=1e-06 w=2e-06
XM4_0 out d1 vdd vdd sky130_fd_pr__pfet_01v8 l=1e-06 w=2e-06
XM4_1 out d1 vdd vdd sky130_fd_pr__pfet_01v8 l=1e-06 w=2e-06
.control
set noaskquit
save v(inp) v(inn) v(out) v(d1) v(tail) @m.xm1_0.msky130_fd_pr__nfet_01v8[vds] @m.xm1_0.msky130_fd_pr__nfet_01v8[vdsat] @m.xm2_0.msky130_fd_pr__nfet_01v8[vds] @m.xm2_0.msky130_fd_pr__nfet_01v8[vdsat] @m.xm3_0.msky130_fd_pr__pfet_01v8[vds] @m.xm3_0.msky130_fd_pr__pfet_01v8[vdsat] @m.xm4_0.msky130_fd_pr__pfet_01v8[vds] @m.xm4_0.msky130_fd_pr__pfet_01v8[vdsat]
dc Vref 0.16 1.75 0.0005
set wr_singlescale
set numdgt=12
wrdata dc.txt v(inp) v(inn) v(out) v(d1) v(tail) @m.xm1_0.msky130_fd_pr__nfet_01v8[vds] @m.xm1_0.msky130_fd_pr__nfet_01v8[vdsat] @m.xm2_0.msky130_fd_pr__nfet_01v8[vds] @m.xm2_0.msky130_fd_pr__nfet_01v8[vdsat] @m.xm3_0.msky130_fd_pr__pfet_01v8[vds] @m.xm3_0.msky130_fd_pr__pfet_01v8[vdsat] @m.xm4_0.msky130_fd_pr__pfet_01v8[vds] @m.xm4_0.msky130_fd_pr__pfet_01v8[vdsat]
quit
.endc
.end
