* u6 toy 5T
.include "C:/pdk/sky130_fd_pr/cells/nfet_01v8/sky130_fd_pr__nfet_01v8__tt.pm3.spice"
.include "C:/pdk/sky130_fd_pr/cells/nfet_01v8/sky130_fd_pr__nfet_01v8__mismatch.corner.spice"
.include "C:/pdk/sky130_fd_pr/models/parameters/lod.spice"
.include "C:/pdk/sky130_fd_pr/cells/pfet_01v8/sky130_fd_pr__pfet_01v8__tt.pm3.spice"
.include "C:/pdk/sky130_fd_pr/cells/pfet_01v8/sky130_fd_pr__pfet_01v8__mismatch.corner.spice"
.temp 27.0
.option gmin=1e-15 reltol=1e-4 abstol=1e-14 vntol=1e-7
Vdd vdd 0 DC 1.8
Vinp inp 0 DC 0.9
IT tail 0 DC 2e-05
CL out 0 1e-12
Esv inn 0 vref out 1e6
Vref vref 0 DC 0.8999991
XM1_0 d1 inp tail 0 sky130_fd_pr__nfet_01v8 l=1e-06 w=2e-06 mult={m_M1}
XM1_1 d1 inp tail 0 sky130_fd_pr__nfet_01v8 l=1e-06 w=2e-06 mult={m_M1}
.param m_M1 = 1e40
XM2_0 out inn tail 0 sky130_fd_pr__nfet_01v8 l=1e-06 w=2e-06 mult={m_M2}
XM2_1 out inn tail 0 sky130_fd_pr__nfet_01v8 l=1e-06 w=2e-06 mult={m_M2}
.param m_M2 = 1e40
XM3_0 d1 d1 vdd vdd sky130_fd_pr__pfet_01v8 l=1e-06 w=2e-06 mult={m_M3}
XM3_1 d1 d1 vdd vdd sky130_fd_pr__pfet_01v8 l=1e-06 w=2e-06 mult={m_M3}
.param m_M3 = 1e40
XM4_0 out d1 vdd vdd sky130_fd_pr__pfet_01v8 l=1e-06 w=2e-06 mult={m_M4}
XM4_1 out d1 vdd vdd sky130_fd_pr__pfet_01v8 l=1e-06 w=2e-06 mult={m_M4}
.param m_M4 = 1e40
.control
set noaskquit
op
echo TAG base
print v(inn)
alterparam m_M1 = 1
alterparam sky130_fd_pr__nfet_01v8__toxe_slope_spectre = 7.071067811865475e-07
reset
op
echo TAG M1:toxe
print v(inn)
alterparam m_M1 = 1e40
alterparam sky130_fd_pr__nfet_01v8__toxe_slope_spectre = 0
reset
alterparam m_M1 = 1
alterparam sky130_fd_pr__nfet_01v8__vth0_slope_spectre = 7.071067811865475e-07
reset
op
echo TAG M1:vth0
print v(inn)
alterparam m_M1 = 1e40
alterparam sky130_fd_pr__nfet_01v8__vth0_slope_spectre = 0
reset
alterparam m_M1 = 1
alterparam sky130_fd_pr__nfet_01v8__voff_slope_spectre = 7.071067811865475e-07
reset
op
echo TAG M1:voff
print v(inn)
alterparam m_M1 = 1e40
alterparam sky130_fd_pr__nfet_01v8__voff_slope_spectre = 0
reset
alterparam m_M2 = 1
alterparam sky130_fd_pr__nfet_01v8__toxe_slope_spectre = 7.071067811865475e-07
reset
op
echo TAG M2:toxe
print v(inn)
alterparam m_M2 = 1e40
alterparam sky130_fd_pr__nfet_01v8__toxe_slope_spectre = 0
reset
alterparam m_M2 = 1
alterparam sky130_fd_pr__nfet_01v8__vth0_slope_spectre = 7.071067811865475e-07
reset
op
echo TAG M2:vth0
print v(inn)
alterparam m_M2 = 1e40
alterparam sky130_fd_pr__nfet_01v8__vth0_slope_spectre = 0
reset
alterparam m_M2 = 1
alterparam sky130_fd_pr__nfet_01v8__voff_slope_spectre = 7.071067811865475e-07
reset
op
echo TAG M2:voff
print v(inn)
alterparam m_M2 = 1e40
alterparam sky130_fd_pr__nfet_01v8__voff_slope_spectre = 0
reset
alterparam m_M3 = 1
alterparam sky130_fd_pr__pfet_01v8__toxe_slope_spectre = 7.071067811865475e-07
reset
op
echo TAG M3:toxe
print v(inn)
alterparam m_M3 = 1e40
alterparam sky130_fd_pr__pfet_01v8__toxe_slope_spectre = 0
reset
alterparam m_M3 = 1
alterparam sky130_fd_pr__pfet_01v8__vth0_slope_spectre = 7.071067811865475e-07
reset
op
echo TAG M3:vth0
print v(inn)
alterparam m_M3 = 1e40
alterparam sky130_fd_pr__pfet_01v8__vth0_slope_spectre = 0
reset
alterparam m_M3 = 1
alterparam sky130_fd_pr__pfet_01v8__voff_slope_spectre = 7.071067811865475e-07
reset
op
echo TAG M3:voff
print v(inn)
alterparam m_M3 = 1e40
alterparam sky130_fd_pr__pfet_01v8__voff_slope_spectre = 0
reset
alterparam m_M3 = 1
alterparam sky130_fd_pr__pfet_01v8__nfactor_slope_spectre = 7.071067811865475e-07
reset
op
echo TAG M3:nfactor
print v(inn)
alterparam m_M3 = 1e40
alterparam sky130_fd_pr__pfet_01v8__nfactor_slope_spectre = 0
reset
alterparam m_M4 = 1
alterparam sky130_fd_pr__pfet_01v8__toxe_slope_spectre = 7.071067811865475e-07
reset
op
echo TAG M4:toxe
print v(inn)
alterparam m_M4 = 1e40
alterparam sky130_fd_pr__pfet_01v8__toxe_slope_spectre = 0
reset
alterparam m_M4 = 1
alterparam sky130_fd_pr__pfet_01v8__vth0_slope_spectre = 7.071067811865475e-07
reset
op
echo TAG M4:vth0
print v(inn)
alterparam m_M4 = 1e40
alterparam sky130_fd_pr__pfet_01v8__vth0_slope_spectre = 0
reset
alterparam m_M4 = 1
alterparam sky130_fd_pr__pfet_01v8__voff_slope_spectre = 7.071067811865475e-07
reset
op
echo TAG M4:voff
print v(inn)
alterparam m_M4 = 1e40
alterparam sky130_fd_pr__pfet_01v8__voff_slope_spectre = 0
reset
alterparam m_M4 = 1
alterparam sky130_fd_pr__pfet_01v8__nfactor_slope_spectre = 7.071067811865475e-07
reset
op
echo TAG M4:nfactor
print v(inn)
alterparam m_M4 = 1e40
alterparam sky130_fd_pr__pfet_01v8__nfactor_slope_spectre = 0
reset
quit
.endc
.end
