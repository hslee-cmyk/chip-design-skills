* spice_oracle: current_reuse_telescopic_ota bias=forced
.include "C:\pdk\sky130_fd_pr\cells\nfet_01v8\sky130_fd_pr__nfet_01v8__tt.pm3.spice"
.include "C:\pdk\sky130_fd_pr\cells\nfet_01v8\sky130_fd_pr__nfet_01v8__mismatch.corner.spice"
.include "C:\pdk\sky130_fd_pr\models\parameters\lod.spice"
.include "C:\pdk\sky130_fd_pr\cells\pfet_01v8\sky130_fd_pr__pfet_01v8__tt.pm3.spice"
.include "C:\pdk\sky130_fd_pr\cells\pfet_01v8\sky130_fd_pr__pfet_01v8__mismatch.corner.spice"
.temp 27
.option gmin=1e-15 reltol=1e-4 abstol=1e-14 vntol=1e-7 itl1=500 itl2=500
Vrail_vdd vdd 0 DC 1.8
XM6 Vx Vbias1 vdd vdd sky130_fd_pr__pfet_01v8 l=4.739047237e-07 w=3.601651421e-05 m=4 ad=1.80082571e-11 as=1.80082571e-11 pd=3.801651421e-05 ps=3.801651421e-05
XM7 Vx Vcmfb vdd vdd sky130_fd_pr__pfet_01v8 l=4.739047237e-07 w=6.294991617e-06 m=4 ad=3.147495808e-12 as=3.147495808e-12 pd=8.294991617e-06 ps=8.294991617e-06
XM1a N1a2a Vip Vx vdd sky130_fd_pr__pfet_01v8 l=5.35e-07 w=3.601651421e-05 m=2 ad=1.80082571e-11 as=1.80082571e-11 pd=3.801651421e-05 ps=3.801651421e-05
XM1b N1b2b Vim Vx vdd sky130_fd_pr__pfet_01v8 l=5.35e-07 w=3.601651421e-05 m=2 ad=1.80082571e-11 as=1.80082571e-11 pd=3.801651421e-05 ps=3.801651421e-05
XM2a Vom1 Vbias2 N1a2a vdd sky130_fd_pr__pfet_01v8 l=1e-06 w=3.601651421e-05 m=2 ad=1.80082571e-11 as=1.80082571e-11 pd=3.801651421e-05 ps=3.801651421e-05
XM2b Vop1 Vbias2 N1b2b vdd sky130_fd_pr__pfet_01v8 l=1e-06 w=3.601651421e-05 m=2 ad=1.80082571e-11 as=1.80082571e-11 pd=3.801651421e-05 ps=3.801651421e-05
XM3a Vom1 Vbias3 N3a4a 0 sky130_fd_pr__nfet_01v8 l=1e-06 w=3.601651421e-05 m=1 ad=1.80082571e-11 as=1.80082571e-11 pd=3.801651421e-05 ps=3.801651421e-05
XM3b Vop1 Vbias3 N3b4b 0 sky130_fd_pr__nfet_01v8 l=1e-06 w=3.601651421e-05 m=1 ad=1.80082571e-11 as=1.80082571e-11 pd=3.801651421e-05 ps=3.801651421e-05
XM4a N3a4a Vip Vy 0 sky130_fd_pr__nfet_01v8 l=1.4e-06 w=3.601651421e-05 m=1 ad=1.80082571e-11 as=1.80082571e-11 pd=3.801651421e-05 ps=3.801651421e-05
XM4b N3b4b Vim Vy 0 sky130_fd_pr__nfet_01v8 l=1.4e-06 w=3.601651421e-05 m=1 ad=1.80082571e-11 as=1.80082571e-11 pd=3.801651421e-05 ps=3.801651421e-05
XM5 Vy Vbias4 0 0 sky130_fd_pr__nfet_01v8 l=5.109106823e-07 w=3.601651421e-05 m=2 ad=1.80082571e-11 as=1.80082571e-11 pd=3.801651421e-05 ps=3.801651421e-05
XM8 Vg15 Vbias1 vdd vdd sky130_fd_pr__pfet_01v8 l=4.739047237e-07 w=3.601651421e-05 m=2 ad=1.80082571e-11 as=1.80082571e-11 pd=3.801651421e-05 ps=3.801651421e-05
XM11a N11a11b N11a11b vdd vdd sky130_fd_pr__pfet_01v8 l=2.45e-07 w=3.601651421e-05 m=1 ad=1.80082571e-11 as=1.80082571e-11 pd=3.801651421e-05 ps=3.801651421e-05
XM11b N11b N11b N11a11b vdd sky130_fd_pr__pfet_01v8 l=2.45e-07 w=3.601651421e-05 m=2 ad=1.80082571e-11 as=1.80082571e-11 pd=3.801651421e-05 ps=3.801651421e-05
XM15 Vom Vg15 vdd vdd sky130_fd_pr__pfet_01v8 l=1.5e-07 w=2.92713437e-06 m=2 ad=1.463567185e-12 as=1.463567185e-12 pd=4.92713437e-06 ps=4.92713437e-06
XM9a Vop1 N11b Vg15 vdd sky130_fd_pr__pfet_01v8 l=1.5e-07 w=3.601651421e-05 m=2 ad=1.80082571e-11 as=1.80082571e-11 pd=3.801651421e-05 ps=3.801651421e-05
XM9b Vg15 N14a14b Vop1 0 sky130_fd_pr__nfet_01v8 l=2.45e-07 w=3.601651421e-05 m=1 ad=1.80082571e-11 as=1.80082571e-11 pd=3.801651421e-05 ps=3.801651421e-05
XM12 N11b Vbias4 0 0 sky130_fd_pr__nfet_01v8 l=5.109106823e-07 w=1.295555046e-06 m=1 ad=6.477775232e-13 as=6.477775232e-13 pd=3.295555046e-06 ps=3.295555046e-06
XM10 Vop1 Vbias4 0 0 sky130_fd_pr__nfet_01v8 l=5.109106823e-07 w=3.601651421e-05 m=1 ad=1.80082571e-11 as=1.80082571e-11 pd=3.801651421e-05 ps=3.801651421e-05
XM14a N14a14b N14a14b N14a_14b 0 sky130_fd_pr__nfet_01v8 l=2.45e-07 w=2.366471985e-06 m=1 ad=1.183235993e-12 as=1.183235993e-12 pd=4.366471985e-06 ps=4.366471985e-06
XM14b N14a_14b N14a_14b 0 0 sky130_fd_pr__nfet_01v8 l=2.45e-07 w=2.366471985e-06 m=1 ad=1.183235993e-12 as=1.183235993e-12 pd=4.366471985e-06 ps=4.366471985e-06
XM16 Vom Vop1 0 0 sky130_fd_pr__nfet_01v8 l=1.5e-07 w=4.548854076e-06 m=2 ad=2.274427038e-12 as=2.274427038e-12 pd=6.548854076e-06 ps=6.548854076e-06
XM13 N14a14b Vbias1 vdd vdd sky130_fd_pr__pfet_01v8 l=4.739047237e-07 w=2.366471985e-06 m=2 ad=1.183235993e-12 as=1.183235993e-12 pd=4.366471985e-06 ps=4.366471985e-06
XM22 N24b23a Vbias1 vdd vdd sky130_fd_pr__pfet_01v8 l=4.739047237e-07 w=2.366471985e-06 m=2 ad=1.183235993e-12 as=1.183235993e-12 pd=4.366471985e-06 ps=4.366471985e-06
XM20a N20a20b N20a20b vdd vdd sky130_fd_pr__pfet_01v8 l=2.45e-07 w=3.601651421e-05 m=1 ad=1.80082571e-11 as=1.80082571e-11 pd=3.801651421e-05 ps=3.801651421e-05
XM20b N20b N20b N20a20b vdd sky130_fd_pr__pfet_01v8 l=2.45e-07 w=3.601651421e-05 m=2 ad=1.80082571e-11 as=1.80082571e-11 pd=3.801651421e-05 ps=3.801651421e-05
XM25 Vop Vg25 vdd vdd sky130_fd_pr__pfet_01v8 l=1.5e-07 w=2.92713437e-06 m=2 ad=1.463567185e-12 as=1.463567185e-12 pd=4.92713437e-06 ps=4.92713437e-06
XM18a Vom1 N20b Vg25 vdd sky130_fd_pr__pfet_01v8 l=1.5e-07 w=3.601651421e-05 m=2 ad=1.80082571e-11 as=1.80082571e-11 pd=3.801651421e-05 ps=3.801651421e-05
XM18b Vg25 N24b23a Vom1 0 sky130_fd_pr__nfet_01v8 l=2.45e-07 w=3.601651421e-05 m=1 ad=1.80082571e-11 as=1.80082571e-11 pd=3.801651421e-05 ps=3.801651421e-05
XM21 N20b Vbias4 0 0 sky130_fd_pr__nfet_01v8 l=5.109106823e-07 w=1.295555046e-06 m=1 ad=6.477775232e-13 as=6.477775232e-13 pd=3.295555046e-06 ps=3.295555046e-06
XM19 Vom1 Vbias4 0 0 sky130_fd_pr__nfet_01v8 l=5.109106823e-07 w=3.601651421e-05 m=1 ad=1.80082571e-11 as=1.80082571e-11 pd=3.801651421e-05 ps=3.801651421e-05
XM23a N24b23a N24b23a N23a24b 0 sky130_fd_pr__nfet_01v8 l=2.45e-07 w=2.366471985e-06 m=1 ad=1.183235993e-12 as=1.183235993e-12 pd=4.366471985e-06 ps=4.366471985e-06
XM24b N23a24b N23a24b 0 0 sky130_fd_pr__nfet_01v8 l=2.45e-07 w=2.366471985e-06 m=1 ad=1.183235993e-12 as=1.183235993e-12 pd=4.366471985e-06 ps=4.366471985e-06
XM26 Vop Vom1 0 0 sky130_fd_pr__nfet_01v8 l=1.5e-07 w=4.548854076e-06 m=2 ad=2.274427038e-12 as=2.274427038e-12 pd=6.548854076e-06 ps=6.548854076e-06
XM17 Vg25 Vbias1 vdd vdd sky130_fd_pr__pfet_01v8 l=4.739047237e-07 w=3.601651421e-05 m=2 ad=1.80082571e-11 as=1.80082571e-11 pd=3.801651421e-05 ps=3.801651421e-05
XM18_bg Vbias1 Vbias1 vdd vdd sky130_fd_pr__pfet_01v8 l=4.739047237e-07 w=4.548854076e-06 m=1 ad=2.274427038e-12 as=2.274427038e-12 pd=6.548854076e-06 ps=6.548854076e-06
XM60 Vbias4 Vbias1 vdd vdd sky130_fd_pr__pfet_01v8 l=4.739047237e-07 w=4.548854076e-06 m=1 ad=2.274427038e-12 as=2.274427038e-12 pd=6.548854076e-06 ps=6.548854076e-06
XM61 Vbias3 Vbias1 vdd vdd sky130_fd_pr__pfet_01v8 l=4.739047237e-07 w=4.548854076e-06 m=1 ad=2.274427038e-12 as=2.274427038e-12 pd=6.548854076e-06 ps=6.548854076e-06
XM64 Vbias3 Vbias3 N64_63 0 sky130_fd_pr__nfet_01v8 l=2.45e-07 w=2.366471985e-06 m=1 ad=1.183235993e-12 as=1.183235993e-12 pd=4.366471985e-06 ps=4.366471985e-06
XM63 N64_63 Vbias3 Vy 0 sky130_fd_pr__nfet_01v8 l=2.45e-07 w=2.366471985e-06 m=1 ad=1.183235993e-12 as=1.183235993e-12 pd=4.366471985e-06 ps=4.366471985e-06
XM58 N58_57 Vbias2 Vx vdd sky130_fd_pr__pfet_01v8 l=3.4e-07 w=3.601651421e-05 m=1 ad=1.80082571e-11 as=1.80082571e-11 pd=3.801651421e-05 ps=3.801651421e-05
XM57 Vbias2 Vbias2 N58_57 vdd sky130_fd_pr__pfet_01v8 l=3.4e-07 w=3.601651421e-05 m=5 ad=1.80082571e-11 as=1.80082571e-11 pd=3.801651421e-05 ps=3.801651421e-05
XM66 Vbias4 Vbias4 0 0 sky130_fd_pr__nfet_01v8 l=5.109106823e-07 w=1.21950152e-06 m=1 ad=6.0975076e-13 as=6.0975076e-13 pd=3.21950152e-06 ps=3.21950152e-06
XM68 Vbias2 Vbias4 0 0 sky130_fd_pr__nfet_01v8 l=5.109106823e-07 w=1.291250561e-06 m=1 ad=6.456252806e-13 as=6.456252806e-13 pd=3.291250561e-06 ps=3.291250561e-06
XM36a Vcmfb Vcmfb vdd vdd sky130_fd_pr__pfet_01v8 l=4.739047237e-07 w=3.601651421e-05 m=5 ad=1.80082571e-11 as=1.80082571e-11 pd=3.801651421e-05 ps=3.801651421e-05
XM36b N36b N36b vdd vdd sky130_fd_pr__pfet_01v8 l=4.739047237e-07 w=3.601651421e-05 m=5 ad=1.80082571e-11 as=1.80082571e-11 pd=3.801651421e-05 ps=3.801651421e-05
XM37a Vcmfb Voc Ncmfb_tail 0 sky130_fd_pr__nfet_01v8 l=3.5e-07 w=3.601651421e-05 m=1 ad=1.80082571e-11 as=1.80082571e-11 pd=3.801651421e-05 ps=3.801651421e-05
XM37b N36b Voc_des Ncmfb_tail 0 sky130_fd_pr__nfet_01v8 l=3.5e-07 w=3.601651421e-05 m=1 ad=1.80082571e-11 as=1.80082571e-11 pd=3.801651421e-05 ps=3.801651421e-05
XM38 Ncmfb_tail Vbias4 0 0 sky130_fd_pr__nfet_01v8 l=5.109106823e-07 w=3.601651421e-05 m=3 ad=1.80082571e-11 as=1.80082571e-11 pd=3.801651421e-05 ps=3.801651421e-05
XM39 Voc_des Voc_des vdd vdd sky130_fd_pr__pfet_01v8 l=3.4e-07 w=4.548854076e-06 m=2 ad=2.274427038e-12 as=2.274427038e-12 pd=6.548854076e-06 ps=6.548854076e-06
XM40 0 0 Voc_des vdd sky130_fd_pr__pfet_01v8 l=3.4e-07 w=4.548854076e-06 m=1 ad=2.274427038e-12 as=2.274427038e-12 pd=6.548854076e-06 ps=6.548854076e-06
Isrc_Iref Vbias1 0 DC 1.992901379e-07
Rp_R1 Vom Voc 1000000000
Rp_R2 Voc Vop 1000000000
Cp_Cc1 Vom N_cc_rz1 5e-13
Rp_Rz1 N_cc_rz1 Vop1 2118.522643
Cp_Cc2 Vop N_cc_rz2 5e-13
Rp_Rz2 N_cc_rz2 Vom1 2118.522643
Cp_CL1 Vop 0 1e-12
Cp_CL2 Vom 0 1e-12
Cp_Cf1 Vom lbx_Vip 5e-13
Cp_Cf2 Vop lbx_Vim 5e-13
Cp_Cs1 lbx_Vip 0 5e-13
Cp_Cs2 lbx_Vim 0 5e-13
Vhold_Vx hs_Vx 0 DC 1.55
Itb_Lhold_Vx hs_Vx Vx DC 0.0001891209
Vhold_Vbias1 hs_Vbias1 0 DC 0.9375
Itb_Lhold_Vbias1 hs_Vbias1 Vbias1 DC -4.79212e-09
Vhold_Vcmfb hs_Vcmfb 0 DC 0.9375
Itb_Lhold_Vcmfb hs_Vcmfb Vcmfb DC 8.753071e-05
Vhold_N1a2a hs_N1a2a 0 DC 0.8772784768
Itb_Lhold_N1a2a hs_N1a2a N1a2a DC -1.43103e-06
Vhold_N1b2b hs_N1b2b 0 DC 0.8772784768
Itb_Lhold_N1b2b hs_N1b2b N1b2b DC -1.43103e-06
Vhold_Vom1 hs_Vom1 0 DC 0.6772784768
Itb_Lhold_Vom1 hs_Vom1 Vom1 DC 0.0004406513
Vhold_Vbias2 hs_Vbias2 0 DC 0.3125
Itb_Lhold_Vbias2 hs_Vbias2 Vbias2 DC 9.508911e-10
Vhold_Vop1 hs_Vop1 0 DC 0.6772784768
Itb_Lhold_Vop1 hs_Vop1 Vop1 DC 0.0004406513
Vhold_Vbias3 hs_Vbias3 0 DC 1.4875
Itb_Lhold_Vbias3 hs_Vbias3 Vbias3 DC 1.950871e-05
Vhold_N3a4a hs_N3a4a 0 DC 0.4772784768
Itb_Lhold_N3a4a hs_N3a4a N3a4a DC -0.000417691
Vhold_N3b4b hs_N3b4b 0 DC 0.4772784768
Itb_Lhold_N3b4b hs_N3b4b N3b4b DC -0.000417691
Vhold_Vy hs_Vy 0 DC 0.02727847682
Itb_Lhold_Vy hs_Vy Vy DC -0.000490789
Vhold_Vbias4 hs_Vbias4 0 DC 0.5625
Itb_Lhold_Vbias4 hs_Vbias4 Vbias4 DC -5.52913e-08
Vhold_Vg15 hs_Vg15 0 DC 0.9750317455
Itb_Lhold_Vg15 hs_Vg15 Vg15 DC -8.22e-07
Vhold_N11a11b hs_N11a11b 0 DC 1.125
Itb_Lhold_N11a11b hs_N11a11b N11a11b DC 5.114181e-07
Vhold_N11b hs_N11b 0 DC 0.3
Itb_Lhold_N11b hs_N11b N11b DC -8.85786e-07
Vhold_Vom hs_Vom 0 DC 0.9
Itb_Lhold_Vom hs_Vom Vom DC -4.55736e-06
Vhold_N14a14b hs_N14a14b 0 DC 1.2375
Itb_Lhold_N14a14b hs_N14a14b N14a14b DC -4.47971e-08
Vhold_N14a_14b hs_N14a_14b 0 DC 0.5625
Itb_Lhold_N14a_14b hs_N14a_14b N14a_14b DC 1.455324e-08
Vhold_N24b23a hs_N24b23a 0 DC 1.2375
Itb_Lhold_N24b23a hs_N24b23a N24b23a DC -4.47971e-08
Vhold_N20a20b hs_N20a20b 0 DC 1.125
Itb_Lhold_N20a20b hs_N20a20b N20a20b DC 5.114181e-07
Vhold_N20b hs_N20b 0 DC 0.3
Itb_Lhold_N20b hs_N20b N20b DC -8.85786e-07
Vhold_Vop hs_Vop 0 DC 0.9
Itb_Lhold_Vop hs_Vop Vop DC -4.55736e-06
Vhold_Vg25 hs_Vg25 0 DC 0.9750317455
Itb_Lhold_Vg25 hs_Vg25 Vg25 DC -8.22e-07
Vhold_N23a24b hs_N23a24b 0 DC 0.5625
Itb_Lhold_N23a24b hs_N23a24b N23a24b DC 1.455324e-08
Vhold_N64_63 hs_N64_63 0 DC 0.5897784768
Itb_Lhold_N64_63 hs_N64_63 N64_63 DC 0.0004465688
Vhold_N58_57 hs_N58_57 0 DC 1.1
Itb_Lhold_N58_57 hs_N58_57 N58_57 DC -0.000191593
Vhold_N36b hs_N36b 0 DC 0.9375
Itb_Lhold_N36b hs_N36b N36b DC -6.36499e-06
Vhold_Voc hs_Voc 0 DC 1.558774902
Itb_Lhold_Voc hs_Voc Voc DC 1.31755e-09
Vhold_Ncmfb_tail hs_Ncmfb_tail 0 DC 0.7375
Itb_Lhold_Ncmfb_tail hs_Ncmfb_tail Ncmfb_tail DC -6.88725e-05
Vhold_Voc_des hs_Voc_des 0 DC 1.0125
Itb_Lhold_Voc_des hs_Voc_des Voc_des DC 5.039761e-08
Vpz_Vip Vip 0 DC 0.6381179
Vpz_Vim Vim 0 DC 0.6381179
Vpz_lbx_Vip lbx_Vip 0 DC 0.6381179
Vpz_lbx_Vim lbx_Vim 0 DC 0.6381179
.nodeset v(vx)=1.55
.nodeset v(vbias1)=0.9375
.nodeset v(vcmfb)=0.9375
.nodeset v(n1a2a)=0.8772785
.nodeset v(n1b2b)=0.8772785
.nodeset v(vom1)=0.6772785
.nodeset v(vbias2)=0.3125
.nodeset v(vop1)=0.6772785
.nodeset v(vbias3)=1.4875
.nodeset v(n3a4a)=0.4772785
.nodeset v(n3b4b)=0.4772785
.nodeset v(vy)=0.02727848
.nodeset v(vbias4)=0.5625
.nodeset v(vg15)=0.9750317
.nodeset v(n11a11b)=1.125
.nodeset v(n11b)=0.3
.nodeset v(vom)=0.9
.nodeset v(n14a14b)=1.2375
.nodeset v(n14a_14b)=0.5625
.nodeset v(n24b23a)=1.2375
.nodeset v(n20a20b)=1.125
.nodeset v(n20b)=0.3
.nodeset v(vop)=0.9
.nodeset v(vg25)=0.9750317
.nodeset v(n23a24b)=0.5625
.nodeset v(n64_63)=0.5897785
.nodeset v(n58_57)=1.1
.nodeset v(n36b)=0.9375
.nodeset v(voc)=1.558775
.nodeset v(ncmfb_tail)=0.7375
.nodeset v(voc_des)=1.0125
.control
set noaskquit
op
echo PZSTART
pz Vop 0 Vop 0 cur pol
print all
echo PZEND
quit
.endc
.end
