* char p

.include "C:\pdk\sky130_fd_pr\cells\nfet_01v8\sky130_fd_pr__nfet_01v8__tt.pm3.spice"
.include "C:\pdk\sky130_fd_pr\cells\nfet_01v8\sky130_fd_pr__nfet_01v8__mismatch.corner.spice"
.include "C:\pdk\sky130_fd_pr\models\parameters\lod.spice"
.include "C:\pdk\sky130_fd_pr\cells\pfet_01v8\sky130_fd_pr__pfet_01v8__tt.pm3.spice"
.include "C:\pdk\sky130_fd_pr\cells\pfet_01v8\sky130_fd_pr__pfet_01v8__mismatch.corner.spice"
.temp 27
Vdd s 0 DC 1.8
Vd d 0 DC 1.2
Vg g 0 DC 1.3
XM d g s s sky130_fd_pr__pfet_01v8 l=5e-07 w=1e-6
.control
set wr_singlescale
set wr_vecnames
option numdgt=10
save @m.xm.msky130_fd_pr__pfet_01v8[id] @m.xm.msky130_fd_pr__pfet_01v8[gm] @m.xm.msky130_fd_pr__pfet_01v8[vdsat] @m.xm.msky130_fd_pr__pfet_01v8[vth]
dc vg 0 1.8 0.005
wrdata C:/Users/HSLEE/Documents/Todoc/fpga/wt/_drafts/evidence/2026-11-01/icmr4/ngcc_3stage_ff_files/char_p.txt @m.xm.msky130_fd_pr__pfet_01v8[id] @m.xm.msky130_fd_pr__pfet_01v8[gm] @m.xm.msky130_fd_pr__pfet_01v8[vdsat] @m.xm.msky130_fd_pr__pfet_01v8[vth]
quit
.endc
.end
