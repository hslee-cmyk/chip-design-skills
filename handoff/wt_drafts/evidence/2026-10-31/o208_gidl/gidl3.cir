* O-202 [0, I_off] check with TERMINAL drain current (includes GIDL, junction) sky130 tt, |VDS|=1.8 V
.include "C:\pdk\sky130_fd_pr\models\parameters\lod.spice"
.include "C:\pdk\sky130_fd_pr\cells\pfet_01v8\sky130_fd_pr__pfet_01v8__tt.pm3.spice"
.include "C:\pdk\sky130_fd_pr\cells\pfet_01v8\sky130_fd_pr__pfet_01v8__mismatch.corner.spice"
.include "C:\pdk\sky130_fd_pr\cells\nfet_01v8\sky130_fd_pr__nfet_01v8__tt.pm3.spice"
.include "C:\pdk\sky130_fd_pr\cells\nfet_01v8\sky130_fd_pr__nfet_01v8__mismatch.corner.spice"
vdd vdd 0 dc 1.8
vgn gn 0 dc 0
vdn1 dn1 0 dc 1.8
vdn2 dn2 0 dc 1.8
xn1 dn1 gn 0 0 sky130_fd_pr__nfet_01v8 l=0.15u w=5u ad=2.5p as=2.5p pd=7u ps=7u
xn2 dn2 gn 0 0 sky130_fd_pr__nfet_01v8 l=1u w=5u ad=2.5p as=2.5p pd=7u ps=7u
vgp gp vdd dc 0
vdp1 dp1 0 dc 0
vdp2 dp2 0 dc 0
xp1 dp1 gp vdd vdd sky130_fd_pr__pfet_01v8 l=0.15u w=5u ad=2.5p as=2.5p pd=7u ps=7u
xp2 dp2 gp vdd vdd sky130_fd_pr__pfet_01v8 l=1u w=5u ad=2.5p as=2.5p pd=7u ps=7u
.options gmin=1e-18
.control
foreach v 0 -0.2 -0.4 -0.6
  alter vgn dc = $v
  op
  echo NVGS $v
  print i(vdn1) i(vdn2)
end
alter vgn dc = 0
foreach v 0 0.2 0.4 0.6
  alter vgp dc = $v
  op
  echo PVSG_NEG $v
  print i(vdp1) i(vdp2)
end
quit
.endc
.end
