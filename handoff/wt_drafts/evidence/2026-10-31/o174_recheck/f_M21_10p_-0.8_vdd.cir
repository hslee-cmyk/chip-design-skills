* F
.include "C:/pdk/sky130_fd_pr/models/parameters/lod.spice"
.include "C:/pdk/sky130_fd_pr/cells/nfet_01v8/sky130_fd_pr__nfet_01v8__tt.pm3.spice"
.include "C:/pdk/sky130_fd_pr/cells/nfet_01v8/sky130_fd_pr__nfet_01v8__mismatch.corner.spice"
.include "C:/pdk/sky130_fd_pr/cells/pfet_01v8/sky130_fd_pr__pfet_01v8__tt.pm3.spice"
.include "C:/pdk/sky130_fd_pr/cells/pfet_01v8/sky130_fd_pr__pfet_01v8__mismatch.corner.spice"
.option gmin=1e-18
vdd vdd 0 1.8
vs s 0 1.1
vg g 0 0.7
vx x 0 pwl(0 0 10n 0 11n -0.8)
x1 d g s vdd sky130_fd_pr__pfet_01v8 w=3u l=1u ad=0.87p as=0.87p pd=6.58u ps=6.58u
cb d x 10p
.ic v(d)=1.1
.control
tran 1n 520n uic
let e = v(d)-v(s)
meas tran pk MAX e
meas tran mn MIN e
meas tran v05 FIND e AT=510n
.endc
.end
