* wi
.include "C:\pdk\sky130_fd_pr\models\parameters\lod.spice"
.include "C:\pdk\sky130_fd_pr\cells\pfet_01v8\sky130_fd_pr__pfet_01v8__tt.pm3.spice"
.include "C:\pdk\sky130_fd_pr\cells\pfet_01v8\sky130_fd_pr__pfet_01v8__mismatch.corner.spice"
vg g 0 dc 0
vd d 0 dc 0
vs s 0 dc 0
vb b 0 dc 0
xdut d g s b sky130_fd_pr__pfet_01v8 l=4.0u w=5u ad=2.5p as=2.5p pd=7u ps=7u
.control
alter vg = -0.5
alter vd = -0.0517
op
echo P
print @m.xdut.msky130_fd_pr__pfet_01v8[id]
print @m.xdut.msky130_fd_pr__pfet_01v8[gm]
print @m.xdut.msky130_fd_pr__pfet_01v8[gds]
destroy all
alter vg = -0.5
alter vd = -0.07756
op
echo P
print @m.xdut.msky130_fd_pr__pfet_01v8[id]
print @m.xdut.msky130_fd_pr__pfet_01v8[gm]
print @m.xdut.msky130_fd_pr__pfet_01v8[gds]
destroy all
alter vg = -0.5
alter vd = -0.10341
op
echo P
print @m.xdut.msky130_fd_pr__pfet_01v8[id]
print @m.xdut.msky130_fd_pr__pfet_01v8[gm]
print @m.xdut.msky130_fd_pr__pfet_01v8[gds]
destroy all
alter vg = -0.5
alter vd = -0.12926
op
echo P
print @m.xdut.msky130_fd_pr__pfet_01v8[id]
print @m.xdut.msky130_fd_pr__pfet_01v8[gm]
print @m.xdut.msky130_fd_pr__pfet_01v8[gds]
destroy all
alter vg = -0.5
alter vd = -0.15511
op
echo P
print @m.xdut.msky130_fd_pr__pfet_01v8[id]
print @m.xdut.msky130_fd_pr__pfet_01v8[gm]
print @m.xdut.msky130_fd_pr__pfet_01v8[gds]
destroy all
alter vg = -0.5
alter vd = -0.20682
op
echo P
print @m.xdut.msky130_fd_pr__pfet_01v8[id]
print @m.xdut.msky130_fd_pr__pfet_01v8[gm]
print @m.xdut.msky130_fd_pr__pfet_01v8[gds]
destroy all
alter vg = -0.5
alter vd = -0.9
op
echo P
print @m.xdut.msky130_fd_pr__pfet_01v8[id]
print @m.xdut.msky130_fd_pr__pfet_01v8[gm]
print @m.xdut.msky130_fd_pr__pfet_01v8[gds]
destroy all
alter vg = -0.6
alter vd = -0.0517
op
echo P
print @m.xdut.msky130_fd_pr__pfet_01v8[id]
print @m.xdut.msky130_fd_pr__pfet_01v8[gm]
print @m.xdut.msky130_fd_pr__pfet_01v8[gds]
destroy all
alter vg = -0.6
alter vd = -0.07756
op
echo P
print @m.xdut.msky130_fd_pr__pfet_01v8[id]
print @m.xdut.msky130_fd_pr__pfet_01v8[gm]
print @m.xdut.msky130_fd_pr__pfet_01v8[gds]
destroy all
alter vg = -0.6
alter vd = -0.10341
op
echo P
print @m.xdut.msky130_fd_pr__pfet_01v8[id]
print @m.xdut.msky130_fd_pr__pfet_01v8[gm]
print @m.xdut.msky130_fd_pr__pfet_01v8[gds]
destroy all
alter vg = -0.6
alter vd = -0.12926
op
echo P
print @m.xdut.msky130_fd_pr__pfet_01v8[id]
print @m.xdut.msky130_fd_pr__pfet_01v8[gm]
print @m.xdut.msky130_fd_pr__pfet_01v8[gds]
destroy all
alter vg = -0.6
alter vd = -0.15511
op
echo P
print @m.xdut.msky130_fd_pr__pfet_01v8[id]
print @m.xdut.msky130_fd_pr__pfet_01v8[gm]
print @m.xdut.msky130_fd_pr__pfet_01v8[gds]
destroy all
alter vg = -0.6
alter vd = -0.20682
op
echo P
print @m.xdut.msky130_fd_pr__pfet_01v8[id]
print @m.xdut.msky130_fd_pr__pfet_01v8[gm]
print @m.xdut.msky130_fd_pr__pfet_01v8[gds]
destroy all
alter vg = -0.6
alter vd = -0.9
op
echo P
print @m.xdut.msky130_fd_pr__pfet_01v8[id]
print @m.xdut.msky130_fd_pr__pfet_01v8[gm]
print @m.xdut.msky130_fd_pr__pfet_01v8[gds]
destroy all
alter vg = -0.7
alter vd = -0.0517
op
echo P
print @m.xdut.msky130_fd_pr__pfet_01v8[id]
print @m.xdut.msky130_fd_pr__pfet_01v8[gm]
print @m.xdut.msky130_fd_pr__pfet_01v8[gds]
destroy all
alter vg = -0.7
alter vd = -0.07756
op
echo P
print @m.xdut.msky130_fd_pr__pfet_01v8[id]
print @m.xdut.msky130_fd_pr__pfet_01v8[gm]
print @m.xdut.msky130_fd_pr__pfet_01v8[gds]
destroy all
alter vg = -0.7
alter vd = -0.10341
op
echo P
print @m.xdut.msky130_fd_pr__pfet_01v8[id]
print @m.xdut.msky130_fd_pr__pfet_01v8[gm]
print @m.xdut.msky130_fd_pr__pfet_01v8[gds]
destroy all
alter vg = -0.7
alter vd = -0.12926
op
echo P
print @m.xdut.msky130_fd_pr__pfet_01v8[id]
print @m.xdut.msky130_fd_pr__pfet_01v8[gm]
print @m.xdut.msky130_fd_pr__pfet_01v8[gds]
destroy all
alter vg = -0.7
alter vd = -0.15511
op
echo P
print @m.xdut.msky130_fd_pr__pfet_01v8[id]
print @m.xdut.msky130_fd_pr__pfet_01v8[gm]
print @m.xdut.msky130_fd_pr__pfet_01v8[gds]
destroy all
alter vg = -0.7
alter vd = -0.20682
op
echo P
print @m.xdut.msky130_fd_pr__pfet_01v8[id]
print @m.xdut.msky130_fd_pr__pfet_01v8[gm]
print @m.xdut.msky130_fd_pr__pfet_01v8[gds]
destroy all
alter vg = -0.7
alter vd = -0.9
op
echo P
print @m.xdut.msky130_fd_pr__pfet_01v8[id]
print @m.xdut.msky130_fd_pr__pfet_01v8[gm]
print @m.xdut.msky130_fd_pr__pfet_01v8[gds]
destroy all
alter vg = -0.8
alter vd = -0.0517
op
echo P
print @m.xdut.msky130_fd_pr__pfet_01v8[id]
print @m.xdut.msky130_fd_pr__pfet_01v8[gm]
print @m.xdut.msky130_fd_pr__pfet_01v8[gds]
destroy all
alter vg = -0.8
alter vd = -0.07756
op
echo P
print @m.xdut.msky130_fd_pr__pfet_01v8[id]
print @m.xdut.msky130_fd_pr__pfet_01v8[gm]
print @m.xdut.msky130_fd_pr__pfet_01v8[gds]
destroy all
alter vg = -0.8
alter vd = -0.10341
op
echo P
print @m.xdut.msky130_fd_pr__pfet_01v8[id]
print @m.xdut.msky130_fd_pr__pfet_01v8[gm]
print @m.xdut.msky130_fd_pr__pfet_01v8[gds]
destroy all
alter vg = -0.8
alter vd = -0.12926
op
echo P
print @m.xdut.msky130_fd_pr__pfet_01v8[id]
print @m.xdut.msky130_fd_pr__pfet_01v8[gm]
print @m.xdut.msky130_fd_pr__pfet_01v8[gds]
destroy all
alter vg = -0.8
alter vd = -0.15511
op
echo P
print @m.xdut.msky130_fd_pr__pfet_01v8[id]
print @m.xdut.msky130_fd_pr__pfet_01v8[gm]
print @m.xdut.msky130_fd_pr__pfet_01v8[gds]
destroy all
alter vg = -0.8
alter vd = -0.20682
op
echo P
print @m.xdut.msky130_fd_pr__pfet_01v8[id]
print @m.xdut.msky130_fd_pr__pfet_01v8[gm]
print @m.xdut.msky130_fd_pr__pfet_01v8[gds]
destroy all
alter vg = -0.8
alter vd = -0.9
op
echo P
print @m.xdut.msky130_fd_pr__pfet_01v8[id]
print @m.xdut.msky130_fd_pr__pfet_01v8[gm]
print @m.xdut.msky130_fd_pr__pfet_01v8[gds]
destroy all
alter vg = -0.9
alter vd = -0.0517
op
echo P
print @m.xdut.msky130_fd_pr__pfet_01v8[id]
print @m.xdut.msky130_fd_pr__pfet_01v8[gm]
print @m.xdut.msky130_fd_pr__pfet_01v8[gds]
destroy all
alter vg = -0.9
alter vd = -0.07756
op
echo P
print @m.xdut.msky130_fd_pr__pfet_01v8[id]
print @m.xdut.msky130_fd_pr__pfet_01v8[gm]
print @m.xdut.msky130_fd_pr__pfet_01v8[gds]
destroy all
alter vg = -0.9
alter vd = -0.10341
op
echo P
print @m.xdut.msky130_fd_pr__pfet_01v8[id]
print @m.xdut.msky130_fd_pr__pfet_01v8[gm]
print @m.xdut.msky130_fd_pr__pfet_01v8[gds]
destroy all
alter vg = -0.9
alter vd = -0.12926
op
echo P
print @m.xdut.msky130_fd_pr__pfet_01v8[id]
print @m.xdut.msky130_fd_pr__pfet_01v8[gm]
print @m.xdut.msky130_fd_pr__pfet_01v8[gds]
destroy all
alter vg = -0.9
alter vd = -0.15511
op
echo P
print @m.xdut.msky130_fd_pr__pfet_01v8[id]
print @m.xdut.msky130_fd_pr__pfet_01v8[gm]
print @m.xdut.msky130_fd_pr__pfet_01v8[gds]
destroy all
alter vg = -0.9
alter vd = -0.20682
op
echo P
print @m.xdut.msky130_fd_pr__pfet_01v8[id]
print @m.xdut.msky130_fd_pr__pfet_01v8[gm]
print @m.xdut.msky130_fd_pr__pfet_01v8[gds]
destroy all
alter vg = -0.9
alter vd = -0.9
op
echo P
print @m.xdut.msky130_fd_pr__pfet_01v8[id]
print @m.xdut.msky130_fd_pr__pfet_01v8[gm]
print @m.xdut.msky130_fd_pr__pfet_01v8[gds]
destroy all
alter vg = -1.0
alter vd = -0.0517
op
echo P
print @m.xdut.msky130_fd_pr__pfet_01v8[id]
print @m.xdut.msky130_fd_pr__pfet_01v8[gm]
print @m.xdut.msky130_fd_pr__pfet_01v8[gds]
destroy all
alter vg = -1.0
alter vd = -0.07756
op
echo P
print @m.xdut.msky130_fd_pr__pfet_01v8[id]
print @m.xdut.msky130_fd_pr__pfet_01v8[gm]
print @m.xdut.msky130_fd_pr__pfet_01v8[gds]
destroy all
alter vg = -1.0
alter vd = -0.10341
op
echo P
print @m.xdut.msky130_fd_pr__pfet_01v8[id]
print @m.xdut.msky130_fd_pr__pfet_01v8[gm]
print @m.xdut.msky130_fd_pr__pfet_01v8[gds]
destroy all
alter vg = -1.0
alter vd = -0.12926
op
echo P
print @m.xdut.msky130_fd_pr__pfet_01v8[id]
print @m.xdut.msky130_fd_pr__pfet_01v8[gm]
print @m.xdut.msky130_fd_pr__pfet_01v8[gds]
destroy all
alter vg = -1.0
alter vd = -0.15511
op
echo P
print @m.xdut.msky130_fd_pr__pfet_01v8[id]
print @m.xdut.msky130_fd_pr__pfet_01v8[gm]
print @m.xdut.msky130_fd_pr__pfet_01v8[gds]
destroy all
alter vg = -1.0
alter vd = -0.20682
op
echo P
print @m.xdut.msky130_fd_pr__pfet_01v8[id]
print @m.xdut.msky130_fd_pr__pfet_01v8[gm]
print @m.xdut.msky130_fd_pr__pfet_01v8[gds]
destroy all
alter vg = -1.0
alter vd = -0.9
op
echo P
print @m.xdut.msky130_fd_pr__pfet_01v8[id]
print @m.xdut.msky130_fd_pr__pfet_01v8[gm]
print @m.xdut.msky130_fd_pr__pfet_01v8[gds]
destroy all
quit
.endc
.end
