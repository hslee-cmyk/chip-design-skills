* 검증 1: ngspice bin 선택 허용오차
vd d 0 1.0
vg g 0 0.6
m1 d g 0 0 nb w=0.49u l=0.5u
m2 d g 0 0 nb w=0.495u l=0.5u
m3 d g 0 0 nb w=0.498u l=0.5u
m4 d g 0 0 nb w=0.499u l=0.5u
m5 d g 0 0 nb w=0.4995u l=0.5u
m6 d g 0 0 nb w=0.4999u l=0.5u
m7 d g 0 0 nb w=0.49999u l=0.5u
m8 d g 0 0 nb w=0.5u l=0.5u
m9 d g 0 0 nb w=0.50001u l=0.5u
m10 d g 0 0 nb w=0.5001u l=0.5u
.model nb.1 nmos level=54 version=4.5 lmin=0.1u lmax=1u wmin=0.1u wmax=0.5u vth0=0.05
.model nb.2 nmos level=54 version=4.5 lmin=0.1u lmax=1u wmin=0.5u wmax=1u vth0=0.55
.control
op
print @m1[vth]
print @m2[vth]
print @m3[vth]
print @m4[vth]
print @m5[vth]
print @m6[vth]
print @m7[vth]
print @m8[vth]
print @m9[vth]
print @m10[vth]
quit
.endc
.end
