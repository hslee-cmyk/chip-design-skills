* erfc_ota bench
.include "C:/pdk/sky130_fd_pr/models/parameters/lod.spice"
.include "C:/pdk/sky130_fd_pr/cells/nfet_01v8/sky130_fd_pr__nfet_01v8__tt.pm3.spice"
.include "C:/pdk/sky130_fd_pr/cells/nfet_01v8/sky130_fd_pr__nfet_01v8__mismatch.corner.spice"
.include "C:/pdk/sky130_fd_pr/cells/pfet_01v8/sky130_fd_pr__pfet_01v8__tt.pm3.spice"
.include "C:/pdk/sky130_fd_pr/cells/pfet_01v8/sky130_fd_pr__pfet_01v8__mismatch.corner.spice"
.option gmin=1e-15 reltol=1e-5 abstol=1e-15 vntol=1e-8 method=gear
vvdd vdd 0 1.8
vvcp vcp 0 0.7
vvcn vcn 0 0.7
xm9 n_m9d n_m7d vdd vdd sky130_fd_pr__pfet_01v8 w=48u l=0.3u ad=13.92p as=13.92p pd=96.58u ps=96.58u
xm10 n_m10d n_m7d vdd vdd sky130_fd_pr__pfet_01v8 w=48u l=0.3u ad=13.92p as=13.92p pd=96.58u ps=96.58u
xm7 n_m7d n_m8g n_m9d vdd sky130_fd_pr__pfet_01v8 w=24u l=0.3u ad=6.96p as=6.96p pd=48.58u ps=48.58u
xm8 out n_m8g n_m10d vdd sky130_fd_pr__pfet_01v8 w=24u l=0.3u ad=6.96p as=6.96p pd=48.58u ps=48.58u
xm21 n_m8g vcn vcp vcp sky130_fd_pr__pfet_01v8 w=3u l=1u ad=0.87p as=0.87p pd=6.58u ps=6.58u
xm13 a n_m13g vdd vdd sky130_fd_pr__pfet_01v8 w=24u l=0.3u ad=6.96p as=6.96p pd=48.58u ps=48.58u
xm14 b n_m14g vdd vdd sky130_fd_pr__pfet_01v8 w=24u l=0.3u ad=6.96p as=6.96p pd=48.58u ps=48.58u
xm11 n_m11d vin_p a vdd sky130_fd_pr__pfet_01v8 w=24u l=0.6u ad=6.96p as=6.96p pd=48.58u ps=48.58u
xm12 n_m12d vin_n b vdd sky130_fd_pr__pfet_01v8 w=24u l=0.6u ad=6.96p as=6.96p pd=48.58u ps=48.58u
xm15 0 n_m11d n_m13g vdd sky130_fd_pr__pfet_01v8 w=1u l=20u ad=0.29p as=0.29p pd=2.58u ps=2.58u
xm16 0 n_m12d n_m14g vdd sky130_fd_pr__pfet_01v8 w=1u l=20u ad=0.29p as=0.29p pd=2.58u ps=2.58u
xm1a n_m5s vin_p b vdd sky130_fd_pr__pfet_01v8 w=24u l=0.6u ad=6.96p as=6.96p pd=48.58u ps=48.58u
xm1b y vin_p b vdd sky130_fd_pr__pfet_01v8 w=24u l=0.6u ad=6.96p as=6.96p pd=48.58u ps=48.58u
xm2b x vin_n a vdd sky130_fd_pr__pfet_01v8 w=24u l=0.6u ad=6.96p as=6.96p pd=48.58u ps=48.58u
xm2a n_m6s vin_n a vdd sky130_fd_pr__pfet_01v8 w=24u l=0.6u ad=6.96p as=6.96p pd=48.58u ps=48.58u
xm5 n_m7d n_m5g n_m5s 0 sky130_fd_pr__nfet_01v8 w=60u l=0.3u ad=17.4p as=17.4p pd=120.6u ps=120.6u
xm6 out n_m6g n_m6s 0 sky130_fd_pr__nfet_01v8 w=60u l=0.3u ad=17.4p as=17.4p pd=120.6u ps=120.6u
xm19 n_m5g z vcn vcn sky130_fd_pr__pfet_01v8 w=3u l=1u ad=0.87p as=0.87p pd=6.58u ps=6.58u
xm20 n_m6g z vcn vcn sky130_fd_pr__pfet_01v8 w=3u l=1u ad=0.87p as=0.87p pd=6.58u ps=6.58u
xm3b n_m5s x 0 0 sky130_fd_pr__nfet_01v8 w=90u l=0.3u ad=26.1p as=26.1p pd=180.6u ps=180.6u
xm4b n_m6s y 0 0 sky130_fd_pr__nfet_01v8 w=90u l=0.3u ad=26.1p as=26.1p pd=180.6u ps=180.6u
xm17b x vcn n_m17ad 0 sky130_fd_pr__nfet_01v8 w=30u l=0.3u ad=8.7p as=8.7p pd=60.58u ps=60.58u
xm17a n_m17ad y 0 0 sky130_fd_pr__nfet_01v8 w=12u l=0.3u ad=3.48p as=3.48p pd=24.58u ps=24.58u
xm3c x vcn n_m3ad 0 sky130_fd_pr__nfet_01v8 w=30u l=0.3u ad=8.7p as=8.7p pd=60.58u ps=60.58u
xm3a n_m3ad z 0 0 sky130_fd_pr__nfet_01v8 w=18u l=0.3u ad=5.22p as=5.22p pd=36.58u ps=36.58u
xm4c y vcn n_m4ad 0 sky130_fd_pr__nfet_01v8 w=30u l=0.3u ad=8.7p as=8.7p pd=60.58u ps=60.58u
xm4a n_m4ad z 0 0 sky130_fd_pr__nfet_01v8 w=18u l=0.3u ad=5.22p as=5.22p pd=36.58u ps=36.58u
xm18b y vcn n_m18ad 0 sky130_fd_pr__nfet_01v8 w=30u l=0.3u ad=8.7p as=8.7p pd=60.58u ps=60.58u
xm18a n_m18ad x 0 0 sky130_fd_pr__nfet_01v8 w=12u l=0.3u ad=3.48p as=3.48p pd=24.58u ps=24.58u
rr1 x z 52000.0
rr2 z y 52000.0
ccbat1_l n_m5g x 1e-12
ccbat1_r n_m6g y 1e-12
ccbat2 n_m7d n_m8g 1e-12
ccl out 0 7e-11
iic_l vdd n_m13g 2e-07
iic_r vdd n_m14g 2e-07
ii05b_l n_m11d 0 1e-06
ii05b_r n_m12d 0 1e-06
rfbk vin_n out 1e-3
vinp vin_p 0 0.6
.control
op
print v(x) v(y) v(z) v(n_m5g) v(n_m6g) v(n_m8g) v(n_m7d) v(n_m5s) v(n_m6s) v(n_m9d) v(n_m10d) v(out) v(a) v(b) i(vvdd)
print @m.xm9.msky130_fd_pr__pfet_01v8[id] @m.xm9.msky130_fd_pr__pfet_01v8[vgs] @m.xm9.msky130_fd_pr__pfet_01v8[vds] @m.xm9.msky130_fd_pr__pfet_01v8[vdsat] @m.xm9.msky130_fd_pr__pfet_01v8[gm] @m.xm9.msky130_fd_pr__pfet_01v8[gds] @m.xm9.msky130_fd_pr__pfet_01v8[cgg]
print @m.xm10.msky130_fd_pr__pfet_01v8[id] @m.xm10.msky130_fd_pr__pfet_01v8[vgs] @m.xm10.msky130_fd_pr__pfet_01v8[vds] @m.xm10.msky130_fd_pr__pfet_01v8[vdsat] @m.xm10.msky130_fd_pr__pfet_01v8[gm] @m.xm10.msky130_fd_pr__pfet_01v8[gds] @m.xm10.msky130_fd_pr__pfet_01v8[cgg]
print @m.xm7.msky130_fd_pr__pfet_01v8[id] @m.xm7.msky130_fd_pr__pfet_01v8[vgs] @m.xm7.msky130_fd_pr__pfet_01v8[vds] @m.xm7.msky130_fd_pr__pfet_01v8[vdsat] @m.xm7.msky130_fd_pr__pfet_01v8[gm] @m.xm7.msky130_fd_pr__pfet_01v8[gds] @m.xm7.msky130_fd_pr__pfet_01v8[cgg]
print @m.xm8.msky130_fd_pr__pfet_01v8[id] @m.xm8.msky130_fd_pr__pfet_01v8[vgs] @m.xm8.msky130_fd_pr__pfet_01v8[vds] @m.xm8.msky130_fd_pr__pfet_01v8[vdsat] @m.xm8.msky130_fd_pr__pfet_01v8[gm] @m.xm8.msky130_fd_pr__pfet_01v8[gds] @m.xm8.msky130_fd_pr__pfet_01v8[cgg]
print @m.xm21.msky130_fd_pr__pfet_01v8[id] @m.xm21.msky130_fd_pr__pfet_01v8[vgs] @m.xm21.msky130_fd_pr__pfet_01v8[vds] @m.xm21.msky130_fd_pr__pfet_01v8[vdsat] @m.xm21.msky130_fd_pr__pfet_01v8[gm] @m.xm21.msky130_fd_pr__pfet_01v8[gds] @m.xm21.msky130_fd_pr__pfet_01v8[cgg]
print @m.xm13.msky130_fd_pr__pfet_01v8[id] @m.xm13.msky130_fd_pr__pfet_01v8[vgs] @m.xm13.msky130_fd_pr__pfet_01v8[vds] @m.xm13.msky130_fd_pr__pfet_01v8[vdsat] @m.xm13.msky130_fd_pr__pfet_01v8[gm] @m.xm13.msky130_fd_pr__pfet_01v8[gds] @m.xm13.msky130_fd_pr__pfet_01v8[cgg]
print @m.xm14.msky130_fd_pr__pfet_01v8[id] @m.xm14.msky130_fd_pr__pfet_01v8[vgs] @m.xm14.msky130_fd_pr__pfet_01v8[vds] @m.xm14.msky130_fd_pr__pfet_01v8[vdsat] @m.xm14.msky130_fd_pr__pfet_01v8[gm] @m.xm14.msky130_fd_pr__pfet_01v8[gds] @m.xm14.msky130_fd_pr__pfet_01v8[cgg]
print @m.xm11.msky130_fd_pr__pfet_01v8[id] @m.xm11.msky130_fd_pr__pfet_01v8[vgs] @m.xm11.msky130_fd_pr__pfet_01v8[vds] @m.xm11.msky130_fd_pr__pfet_01v8[vdsat] @m.xm11.msky130_fd_pr__pfet_01v8[gm] @m.xm11.msky130_fd_pr__pfet_01v8[gds] @m.xm11.msky130_fd_pr__pfet_01v8[cgg]
print @m.xm12.msky130_fd_pr__pfet_01v8[id] @m.xm12.msky130_fd_pr__pfet_01v8[vgs] @m.xm12.msky130_fd_pr__pfet_01v8[vds] @m.xm12.msky130_fd_pr__pfet_01v8[vdsat] @m.xm12.msky130_fd_pr__pfet_01v8[gm] @m.xm12.msky130_fd_pr__pfet_01v8[gds] @m.xm12.msky130_fd_pr__pfet_01v8[cgg]
print @m.xm15.msky130_fd_pr__pfet_01v8[id] @m.xm15.msky130_fd_pr__pfet_01v8[vgs] @m.xm15.msky130_fd_pr__pfet_01v8[vds] @m.xm15.msky130_fd_pr__pfet_01v8[vdsat] @m.xm15.msky130_fd_pr__pfet_01v8[gm] @m.xm15.msky130_fd_pr__pfet_01v8[gds] @m.xm15.msky130_fd_pr__pfet_01v8[cgg]
print @m.xm16.msky130_fd_pr__pfet_01v8[id] @m.xm16.msky130_fd_pr__pfet_01v8[vgs] @m.xm16.msky130_fd_pr__pfet_01v8[vds] @m.xm16.msky130_fd_pr__pfet_01v8[vdsat] @m.xm16.msky130_fd_pr__pfet_01v8[gm] @m.xm16.msky130_fd_pr__pfet_01v8[gds] @m.xm16.msky130_fd_pr__pfet_01v8[cgg]
print @m.xm1a.msky130_fd_pr__pfet_01v8[id] @m.xm1a.msky130_fd_pr__pfet_01v8[vgs] @m.xm1a.msky130_fd_pr__pfet_01v8[vds] @m.xm1a.msky130_fd_pr__pfet_01v8[vdsat] @m.xm1a.msky130_fd_pr__pfet_01v8[gm] @m.xm1a.msky130_fd_pr__pfet_01v8[gds] @m.xm1a.msky130_fd_pr__pfet_01v8[cgg]
print @m.xm1b.msky130_fd_pr__pfet_01v8[id] @m.xm1b.msky130_fd_pr__pfet_01v8[vgs] @m.xm1b.msky130_fd_pr__pfet_01v8[vds] @m.xm1b.msky130_fd_pr__pfet_01v8[vdsat] @m.xm1b.msky130_fd_pr__pfet_01v8[gm] @m.xm1b.msky130_fd_pr__pfet_01v8[gds] @m.xm1b.msky130_fd_pr__pfet_01v8[cgg]
print @m.xm2b.msky130_fd_pr__pfet_01v8[id] @m.xm2b.msky130_fd_pr__pfet_01v8[vgs] @m.xm2b.msky130_fd_pr__pfet_01v8[vds] @m.xm2b.msky130_fd_pr__pfet_01v8[vdsat] @m.xm2b.msky130_fd_pr__pfet_01v8[gm] @m.xm2b.msky130_fd_pr__pfet_01v8[gds] @m.xm2b.msky130_fd_pr__pfet_01v8[cgg]
print @m.xm2a.msky130_fd_pr__pfet_01v8[id] @m.xm2a.msky130_fd_pr__pfet_01v8[vgs] @m.xm2a.msky130_fd_pr__pfet_01v8[vds] @m.xm2a.msky130_fd_pr__pfet_01v8[vdsat] @m.xm2a.msky130_fd_pr__pfet_01v8[gm] @m.xm2a.msky130_fd_pr__pfet_01v8[gds] @m.xm2a.msky130_fd_pr__pfet_01v8[cgg]
print @m.xm5.msky130_fd_pr__nfet_01v8[id] @m.xm5.msky130_fd_pr__nfet_01v8[vgs] @m.xm5.msky130_fd_pr__nfet_01v8[vds] @m.xm5.msky130_fd_pr__nfet_01v8[vdsat] @m.xm5.msky130_fd_pr__nfet_01v8[gm] @m.xm5.msky130_fd_pr__nfet_01v8[gds] @m.xm5.msky130_fd_pr__nfet_01v8[cgg]
print @m.xm6.msky130_fd_pr__nfet_01v8[id] @m.xm6.msky130_fd_pr__nfet_01v8[vgs] @m.xm6.msky130_fd_pr__nfet_01v8[vds] @m.xm6.msky130_fd_pr__nfet_01v8[vdsat] @m.xm6.msky130_fd_pr__nfet_01v8[gm] @m.xm6.msky130_fd_pr__nfet_01v8[gds] @m.xm6.msky130_fd_pr__nfet_01v8[cgg]
print @m.xm19.msky130_fd_pr__pfet_01v8[id] @m.xm19.msky130_fd_pr__pfet_01v8[vgs] @m.xm19.msky130_fd_pr__pfet_01v8[vds] @m.xm19.msky130_fd_pr__pfet_01v8[vdsat] @m.xm19.msky130_fd_pr__pfet_01v8[gm] @m.xm19.msky130_fd_pr__pfet_01v8[gds] @m.xm19.msky130_fd_pr__pfet_01v8[cgg]
print @m.xm20.msky130_fd_pr__pfet_01v8[id] @m.xm20.msky130_fd_pr__pfet_01v8[vgs] @m.xm20.msky130_fd_pr__pfet_01v8[vds] @m.xm20.msky130_fd_pr__pfet_01v8[vdsat] @m.xm20.msky130_fd_pr__pfet_01v8[gm] @m.xm20.msky130_fd_pr__pfet_01v8[gds] @m.xm20.msky130_fd_pr__pfet_01v8[cgg]
print @m.xm3b.msky130_fd_pr__nfet_01v8[id] @m.xm3b.msky130_fd_pr__nfet_01v8[vgs] @m.xm3b.msky130_fd_pr__nfet_01v8[vds] @m.xm3b.msky130_fd_pr__nfet_01v8[vdsat] @m.xm3b.msky130_fd_pr__nfet_01v8[gm] @m.xm3b.msky130_fd_pr__nfet_01v8[gds] @m.xm3b.msky130_fd_pr__nfet_01v8[cgg]
print @m.xm4b.msky130_fd_pr__nfet_01v8[id] @m.xm4b.msky130_fd_pr__nfet_01v8[vgs] @m.xm4b.msky130_fd_pr__nfet_01v8[vds] @m.xm4b.msky130_fd_pr__nfet_01v8[vdsat] @m.xm4b.msky130_fd_pr__nfet_01v8[gm] @m.xm4b.msky130_fd_pr__nfet_01v8[gds] @m.xm4b.msky130_fd_pr__nfet_01v8[cgg]
print @m.xm17b.msky130_fd_pr__nfet_01v8[id] @m.xm17b.msky130_fd_pr__nfet_01v8[vgs] @m.xm17b.msky130_fd_pr__nfet_01v8[vds] @m.xm17b.msky130_fd_pr__nfet_01v8[vdsat] @m.xm17b.msky130_fd_pr__nfet_01v8[gm] @m.xm17b.msky130_fd_pr__nfet_01v8[gds] @m.xm17b.msky130_fd_pr__nfet_01v8[cgg]
print @m.xm17a.msky130_fd_pr__nfet_01v8[id] @m.xm17a.msky130_fd_pr__nfet_01v8[vgs] @m.xm17a.msky130_fd_pr__nfet_01v8[vds] @m.xm17a.msky130_fd_pr__nfet_01v8[vdsat] @m.xm17a.msky130_fd_pr__nfet_01v8[gm] @m.xm17a.msky130_fd_pr__nfet_01v8[gds] @m.xm17a.msky130_fd_pr__nfet_01v8[cgg]
print @m.xm3c.msky130_fd_pr__nfet_01v8[id] @m.xm3c.msky130_fd_pr__nfet_01v8[vgs] @m.xm3c.msky130_fd_pr__nfet_01v8[vds] @m.xm3c.msky130_fd_pr__nfet_01v8[vdsat] @m.xm3c.msky130_fd_pr__nfet_01v8[gm] @m.xm3c.msky130_fd_pr__nfet_01v8[gds] @m.xm3c.msky130_fd_pr__nfet_01v8[cgg]
print @m.xm3a.msky130_fd_pr__nfet_01v8[id] @m.xm3a.msky130_fd_pr__nfet_01v8[vgs] @m.xm3a.msky130_fd_pr__nfet_01v8[vds] @m.xm3a.msky130_fd_pr__nfet_01v8[vdsat] @m.xm3a.msky130_fd_pr__nfet_01v8[gm] @m.xm3a.msky130_fd_pr__nfet_01v8[gds] @m.xm3a.msky130_fd_pr__nfet_01v8[cgg]
print @m.xm4c.msky130_fd_pr__nfet_01v8[id] @m.xm4c.msky130_fd_pr__nfet_01v8[vgs] @m.xm4c.msky130_fd_pr__nfet_01v8[vds] @m.xm4c.msky130_fd_pr__nfet_01v8[vdsat] @m.xm4c.msky130_fd_pr__nfet_01v8[gm] @m.xm4c.msky130_fd_pr__nfet_01v8[gds] @m.xm4c.msky130_fd_pr__nfet_01v8[cgg]
print @m.xm4a.msky130_fd_pr__nfet_01v8[id] @m.xm4a.msky130_fd_pr__nfet_01v8[vgs] @m.xm4a.msky130_fd_pr__nfet_01v8[vds] @m.xm4a.msky130_fd_pr__nfet_01v8[vdsat] @m.xm4a.msky130_fd_pr__nfet_01v8[gm] @m.xm4a.msky130_fd_pr__nfet_01v8[gds] @m.xm4a.msky130_fd_pr__nfet_01v8[cgg]
print @m.xm18b.msky130_fd_pr__nfet_01v8[id] @m.xm18b.msky130_fd_pr__nfet_01v8[vgs] @m.xm18b.msky130_fd_pr__nfet_01v8[vds] @m.xm18b.msky130_fd_pr__nfet_01v8[vdsat] @m.xm18b.msky130_fd_pr__nfet_01v8[gm] @m.xm18b.msky130_fd_pr__nfet_01v8[gds] @m.xm18b.msky130_fd_pr__nfet_01v8[cgg]
print @m.xm18a.msky130_fd_pr__nfet_01v8[id] @m.xm18a.msky130_fd_pr__nfet_01v8[vgs] @m.xm18a.msky130_fd_pr__nfet_01v8[vds] @m.xm18a.msky130_fd_pr__nfet_01v8[vdsat] @m.xm18a.msky130_fd_pr__nfet_01v8[gm] @m.xm18a.msky130_fd_pr__nfet_01v8[gds] @m.xm18a.msky130_fd_pr__nfet_01v8[cgg]
.endc
.end
