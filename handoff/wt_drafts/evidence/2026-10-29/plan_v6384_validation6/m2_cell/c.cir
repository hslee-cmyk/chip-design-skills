* cell
.include "C:/pdk/sky130_fd_pr/models/r+c/res_typical__cap_typical__lin.spice"
.param sky130_fd_pr__res_high_po__slope_spectre = 0.0 sky130_fd_pr__res_high_po__con_slope_spectre = 0.0
.param crpf_precision = 0.000106 crpfsw_precision_1_1 = 5.04e-11
.include "C:/pdk/sky130_fd_pr/cells/res_high_po/sky130_fd_pr__res_high_po_0p35.model.spice"
v1 a 0 dc 0.5 ac 1
vb b 0 dc 0
x1 a 0 b sky130_fd_pr__res_high_po_0p35 l=898.9491284688199 w=0.35
.control
op
print -i(v1)
ac lin 1 1k 1k
print imag(-i(v1))
quit
.endc
.end
