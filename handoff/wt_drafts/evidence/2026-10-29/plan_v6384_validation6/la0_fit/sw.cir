* sweep
.include "C:\pdk\sky130_fd_pr\models\parameters\lod.spice"
.include "C:\pdk\sky130_fd_pr\cells\pfet_01v8\sky130_fd_pr__pfet_01v8__tt.pm3.spice"
.include "C:\pdk\sky130_fd_pr\cells\pfet_01v8\sky130_fd_pr__pfet_01v8__mismatch.corner.spice"
vg g 0 dc -1.199
vd d 0 dc 0
vs s 0 dc 0
vb b 0 dc 0
xdut d g s b sky130_fd_pr__pfet_01v8 l=4.0u w=5u ad=2.5p as=2.5p pd=7u ps=7u
.control
dc vd 0 -0.9 -0.002
wrdata C:/Users/HSLEE/Documents/Todoc/fpga/wt/_drafts/evidence/2026-10-29/plan_v6384_validation6/la0_fit/sw.dat i(vd)
quit
.endc
.end
