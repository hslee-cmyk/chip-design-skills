* s
.include "C:\pdk\sky130_fd_pr\models\parameters\lod.spice"
.include "C:\pdk\sky130_fd_pr\cells\nfet_01v8\sky130_fd_pr__nfet_01v8__tt.pm3.spice"
.include "C:\pdk\sky130_fd_pr\cells\nfet_01v8\sky130_fd_pr__nfet_01v8__mismatch.corner.spice"
vx x 0 dc 0
vg g x dc 1.2
vd d 0 dc 1.8
vs s 0 dc 0
vb b x dc 0
xdut d g s b sky130_fd_pr__nfet_01v8 l=4.0u w=5u ad=2.5p as=2.5p pd=7u ps=7u
.save @m.xdut.msky130_fd_pr__nfet_01v8[vdsat] @m.xdut.msky130_fd_pr__nfet_01v8[id]
.control
dc vx 0 -1.8 -0.001
wrdata C:/Users/HSLEE/Documents/Todoc/fpga/wt/_drafts/evidence/2026-10-29/plan_v6384_validation7/nj2_sat/rv.dat @m.xdut.msky130_fd_pr__nfet_01v8[id] @m.xdut.msky130_fd_pr__nfet_01v8[vdsat]
quit
.endc
.end
