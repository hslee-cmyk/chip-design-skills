* cgg
.include "C:/pdk/sky130_fd_pr/models/parameters/lod.spice"
.include "C:/pdk/sky130_fd_pr/cells/nfet_01v8/sky130_fd_pr__nfet_01v8__tt.pm3.spice"
.include "C:/pdk/sky130_fd_pr/cells/nfet_01v8/sky130_fd_pr__nfet_01v8__mismatch.corner.spice"
.include "C:/pdk/sky130_fd_pr/cells/pfet_01v8/sky130_fd_pr__pfet_01v8__tt.pm3.spice"
.include "C:/pdk/sky130_fd_pr/cells/pfet_01v8/sky130_fd_pr__pfet_01v8__mismatch.corner.spice"
vd d 0 1.8
vg g 0 0
vs s 0 1.8
vb b 0 1.8
x1 d g s b sky130_fd_pr__pfet_01v8 w=24u l=0.3u
.control
op
print @m.x1.msky130_fd_pr__pfet_01v8[cgg]
.endc
.end
