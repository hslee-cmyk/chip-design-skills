* spice_harness: current_reuse_telescopic_ota  w_source=layout finger_mode=layout
.include "C:\pdk\sky130_fd_pr\cells\nfet_01v8\sky130_fd_pr__nfet_01v8__tt.pm3.spice"
.include "C:\pdk\sky130_fd_pr\cells\nfet_01v8\sky130_fd_pr__nfet_01v8__mismatch.corner.spice"
.include "C:\pdk\sky130_fd_pr\cells\pfet_01v8\sky130_fd_pr__pfet_01v8__tt.pm3.spice"
.include "C:\pdk\sky130_fd_pr\cells\pfet_01v8\sky130_fd_pr__pfet_01v8__mismatch.corner.spice"
.include "C:\pdk\sky130_fd_pr\models\parameters\lod.spice"
.temp 27.0
.option gmin=1e-15 reltol=1e-4 abstol=1e-14 vntol=1e-7 itl1=500 itl2=500
Vvdd vdd 0 DC 1.8
XM6_p0 Vx Vbias1 vdd vdd sky130_fd_pr__pfet_01v8 l=0.473905u w=36.016514u nf=1 ad=18.008257p as=18.008257p pd=38.016514u ps=38.016514u
XM6_p1 Vx Vbias1 vdd vdd sky130_fd_pr__pfet_01v8 l=0.473905u w=36.016514u nf=1 ad=18.008257p as=18.008257p pd=38.016514u ps=38.016514u
XM6_p2 Vx Vbias1 vdd vdd sky130_fd_pr__pfet_01v8 l=0.473905u w=36.016514u nf=1 ad=18.008257p as=18.008257p pd=38.016514u ps=38.016514u
XM6_p3 Vx Vbias1 vdd vdd sky130_fd_pr__pfet_01v8 l=0.473905u w=36.016514u nf=1 ad=18.008257p as=18.008257p pd=38.016514u ps=38.016514u
XM7_p0 Vx Vcmfb vdd vdd sky130_fd_pr__pfet_01v8 l=0.473905u w=6.294992u nf=1 ad=3.147496p as=3.147496p pd=8.294992u ps=8.294992u
XM7_p1 Vx Vcmfb vdd vdd sky130_fd_pr__pfet_01v8 l=0.473905u w=6.294992u nf=1 ad=3.147496p as=3.147496p pd=8.294992u ps=8.294992u
XM7_p2 Vx Vcmfb vdd vdd sky130_fd_pr__pfet_01v8 l=0.473905u w=6.294992u nf=1 ad=3.147496p as=3.147496p pd=8.294992u ps=8.294992u
XM7_p3 Vx Vcmfb vdd vdd sky130_fd_pr__pfet_01v8 l=0.473905u w=6.294992u nf=1 ad=3.147496p as=3.147496p pd=8.294992u ps=8.294992u
XM1a_p0 N1a2a Vip Vx vdd sky130_fd_pr__pfet_01v8 l=0.535000u w=36.016514u nf=1 ad=18.008257p as=18.008257p pd=38.016514u ps=38.016514u
XM1a_p1 N1a2a Vip Vx vdd sky130_fd_pr__pfet_01v8 l=0.535000u w=36.016514u nf=1 ad=18.008257p as=18.008257p pd=38.016514u ps=38.016514u
XM1b_p0 N1b2b Vim Vx vdd sky130_fd_pr__pfet_01v8 l=0.535000u w=36.016514u nf=1 ad=18.008257p as=18.008257p pd=38.016514u ps=38.016514u
XM1b_p1 N1b2b Vim Vx vdd sky130_fd_pr__pfet_01v8 l=0.535000u w=36.016514u nf=1 ad=18.008257p as=18.008257p pd=38.016514u ps=38.016514u
XM2a_p0 Vom1 Vbias2 N1a2a vdd sky130_fd_pr__pfet_01v8 l=1.000000u w=36.016514u nf=1 ad=18.008257p as=18.008257p pd=38.016514u ps=38.016514u
XM2a_p1 Vom1 Vbias2 N1a2a vdd sky130_fd_pr__pfet_01v8 l=1.000000u w=36.016514u nf=1 ad=18.008257p as=18.008257p pd=38.016514u ps=38.016514u
XM2b_p0 Vop1 Vbias2 N1b2b vdd sky130_fd_pr__pfet_01v8 l=1.000000u w=36.016514u nf=1 ad=18.008257p as=18.008257p pd=38.016514u ps=38.016514u
XM2b_p1 Vop1 Vbias2 N1b2b vdd sky130_fd_pr__pfet_01v8 l=1.000000u w=36.016514u nf=1 ad=18.008257p as=18.008257p pd=38.016514u ps=38.016514u
XM3a Vom1 Vbias3 N3a4a 0 sky130_fd_pr__nfet_01v8 l=1.000000u w=36.016514u nf=1 ad=18.008257p as=18.008257p pd=38.016514u ps=38.016514u
XM3b Vop1 Vbias3 N3b4b 0 sky130_fd_pr__nfet_01v8 l=1.000000u w=36.016514u nf=1 ad=18.008257p as=18.008257p pd=38.016514u ps=38.016514u
XM4a N3a4a Vip Vy 0 sky130_fd_pr__nfet_01v8 l=1.400000u w=36.016514u nf=1 ad=18.008257p as=18.008257p pd=38.016514u ps=38.016514u
XM4b N3b4b Vim Vy 0 sky130_fd_pr__nfet_01v8 l=1.400000u w=36.016514u nf=1 ad=18.008257p as=18.008257p pd=38.016514u ps=38.016514u
XM5_p0 Vy Vbias4 0 0 sky130_fd_pr__nfet_01v8 l=0.510911u w=36.016514u nf=1 ad=18.008257p as=18.008257p pd=38.016514u ps=38.016514u
XM5_p1 Vy Vbias4 0 0 sky130_fd_pr__nfet_01v8 l=0.510911u w=36.016514u nf=1 ad=18.008257p as=18.008257p pd=38.016514u ps=38.016514u
XM8_p0 Vg15 Vbias1 vdd vdd sky130_fd_pr__pfet_01v8 l=0.473905u w=36.016514u nf=1 ad=18.008257p as=18.008257p pd=38.016514u ps=38.016514u
XM8_p1 Vg15 Vbias1 vdd vdd sky130_fd_pr__pfet_01v8 l=0.473905u w=36.016514u nf=1 ad=18.008257p as=18.008257p pd=38.016514u ps=38.016514u
XM11a N11a11b N11a11b vdd vdd sky130_fd_pr__pfet_01v8 l=0.245000u w=36.016514u nf=1 ad=18.008257p as=18.008257p pd=38.016514u ps=38.016514u
XM11b_p0 N11b N11b N11a11b vdd sky130_fd_pr__pfet_01v8 l=0.245000u w=18.008257u nf=1 ad=9.004129p as=9.004129p pd=20.008257u ps=20.008257u
XM11b_p1 N11b N11b N11a11b vdd sky130_fd_pr__pfet_01v8 l=0.245000u w=18.008257u nf=1 ad=9.004129p as=9.004129p pd=20.008257u ps=20.008257u
XM15_p0 Vom Vg15 vdd vdd sky130_fd_pr__pfet_01v8 l=0.150000u w=2.927134u nf=1 ad=1.463567p as=1.463567p pd=4.927134u ps=4.927134u
XM15_p1 Vom Vg15 vdd vdd sky130_fd_pr__pfet_01v8 l=0.150000u w=2.927134u nf=1 ad=1.463567p as=1.463567p pd=4.927134u ps=4.927134u
XM9a_p0 Vop1 N11b Vg15 vdd sky130_fd_pr__pfet_01v8 l=0.150000u w=36.016514u nf=1 ad=18.008257p as=18.008257p pd=38.016514u ps=38.016514u
XM9a_p1 Vop1 N11b Vg15 vdd sky130_fd_pr__pfet_01v8 l=0.150000u w=36.016514u nf=1 ad=18.008257p as=18.008257p pd=38.016514u ps=38.016514u
XM9b Vg15 N14a14b Vop1 0 sky130_fd_pr__nfet_01v8 l=0.245000u w=36.016514u nf=1 ad=18.008257p as=18.008257p pd=38.016514u ps=38.016514u
XM12 N11b Vbias4 0 0 sky130_fd_pr__nfet_01v8 l=0.510911u w=1.295555u nf=1 ad=0.647778p as=0.647778p pd=3.295555u ps=3.295555u
XM10 Vop1 Vbias4 0 0 sky130_fd_pr__nfet_01v8 l=0.510911u w=36.016514u nf=1 ad=18.008257p as=18.008257p pd=38.016514u ps=38.016514u
XM14a N14a14b N14a14b N14a_14b 0 sky130_fd_pr__nfet_01v8 l=0.245000u w=2.366472u nf=1 ad=1.183236p as=1.183236p pd=4.366472u ps=4.366472u
XM14b N14a_14b N14a_14b 0 0 sky130_fd_pr__nfet_01v8 l=0.245000u w=2.366472u nf=1 ad=1.183236p as=1.183236p pd=4.366472u ps=4.366472u
XM16_p0 Vom Vop1 0 0 sky130_fd_pr__nfet_01v8 l=0.150000u w=4.548854u nf=1 ad=2.274427p as=2.274427p pd=6.548854u ps=6.548854u
XM16_p1 Vom Vop1 0 0 sky130_fd_pr__nfet_01v8 l=0.150000u w=4.548854u nf=1 ad=2.274427p as=2.274427p pd=6.548854u ps=6.548854u
XM13_p0 N14a14b Vbias1 vdd vdd sky130_fd_pr__pfet_01v8 l=0.473905u w=2.366472u nf=1 ad=1.183236p as=1.183236p pd=4.366472u ps=4.366472u
XM13_p1 N14a14b Vbias1 vdd vdd sky130_fd_pr__pfet_01v8 l=0.473905u w=2.366472u nf=1 ad=1.183236p as=1.183236p pd=4.366472u ps=4.366472u
XM22_p0 N24b23a Vbias1 vdd vdd sky130_fd_pr__pfet_01v8 l=0.473905u w=2.366472u nf=1 ad=1.183236p as=1.183236p pd=4.366472u ps=4.366472u
XM22_p1 N24b23a Vbias1 vdd vdd sky130_fd_pr__pfet_01v8 l=0.473905u w=2.366472u nf=1 ad=1.183236p as=1.183236p pd=4.366472u ps=4.366472u
XM20a N20a20b N20a20b vdd vdd sky130_fd_pr__pfet_01v8 l=0.245000u w=36.016514u nf=1 ad=18.008257p as=18.008257p pd=38.016514u ps=38.016514u
XM20b_p0 N20b N20b N20a20b vdd sky130_fd_pr__pfet_01v8 l=0.245000u w=18.008257u nf=1 ad=9.004129p as=9.004129p pd=20.008257u ps=20.008257u
XM20b_p1 N20b N20b N20a20b vdd sky130_fd_pr__pfet_01v8 l=0.245000u w=18.008257u nf=1 ad=9.004129p as=9.004129p pd=20.008257u ps=20.008257u
XM25_p0 Vop Vg25 vdd vdd sky130_fd_pr__pfet_01v8 l=0.150000u w=2.927134u nf=1 ad=1.463567p as=1.463567p pd=4.927134u ps=4.927134u
XM25_p1 Vop Vg25 vdd vdd sky130_fd_pr__pfet_01v8 l=0.150000u w=2.927134u nf=1 ad=1.463567p as=1.463567p pd=4.927134u ps=4.927134u
XM18a_p0 Vom1 N20b Vg25 vdd sky130_fd_pr__pfet_01v8 l=0.150000u w=36.016514u nf=1 ad=18.008257p as=18.008257p pd=38.016514u ps=38.016514u
XM18a_p1 Vom1 N20b Vg25 vdd sky130_fd_pr__pfet_01v8 l=0.150000u w=36.016514u nf=1 ad=18.008257p as=18.008257p pd=38.016514u ps=38.016514u
XM18b Vg25 N24b23a Vom1 0 sky130_fd_pr__nfet_01v8 l=0.245000u w=36.016514u nf=1 ad=18.008257p as=18.008257p pd=38.016514u ps=38.016514u
XM21 N20b Vbias4 0 0 sky130_fd_pr__nfet_01v8 l=0.510911u w=1.295555u nf=1 ad=0.647778p as=0.647778p pd=3.295555u ps=3.295555u
XM19 Vom1 Vbias4 0 0 sky130_fd_pr__nfet_01v8 l=0.510911u w=36.016514u nf=1 ad=18.008257p as=18.008257p pd=38.016514u ps=38.016514u
XM23a N24b23a N24b23a N23a24b 0 sky130_fd_pr__nfet_01v8 l=0.245000u w=2.366472u nf=1 ad=1.183236p as=1.183236p pd=4.366472u ps=4.366472u
XM24b N23a24b N23a24b 0 0 sky130_fd_pr__nfet_01v8 l=0.245000u w=2.366472u nf=1 ad=1.183236p as=1.183236p pd=4.366472u ps=4.366472u
XM26_p0 Vop Vom1 0 0 sky130_fd_pr__nfet_01v8 l=0.150000u w=4.548854u nf=1 ad=2.274427p as=2.274427p pd=6.548854u ps=6.548854u
XM26_p1 Vop Vom1 0 0 sky130_fd_pr__nfet_01v8 l=0.150000u w=4.548854u nf=1 ad=2.274427p as=2.274427p pd=6.548854u ps=6.548854u
XM17_p0 Vg25 Vbias1 vdd vdd sky130_fd_pr__pfet_01v8 l=0.473905u w=36.016514u nf=1 ad=18.008257p as=18.008257p pd=38.016514u ps=38.016514u
XM17_p1 Vg25 Vbias1 vdd vdd sky130_fd_pr__pfet_01v8 l=0.473905u w=36.016514u nf=1 ad=18.008257p as=18.008257p pd=38.016514u ps=38.016514u
XM18_bg Vbias1 Vbias1 vdd vdd sky130_fd_pr__pfet_01v8 l=0.473905u w=4.548854u nf=1 ad=2.274427p as=2.274427p pd=6.548854u ps=6.548854u
XM60 Vbias4 Vbias1 vdd vdd sky130_fd_pr__pfet_01v8 l=0.473905u w=4.548854u nf=1 ad=2.274427p as=2.274427p pd=6.548854u ps=6.548854u
XM61 Vbias3 Vbias1 vdd vdd sky130_fd_pr__pfet_01v8 l=0.473905u w=4.548854u nf=1 ad=2.274427p as=2.274427p pd=6.548854u ps=6.548854u
XM64 Vbias3 Vbias3 N64_63 0 sky130_fd_pr__nfet_01v8 l=0.245000u w=2.366472u nf=1 ad=1.183236p as=1.183236p pd=4.366472u ps=4.366472u
XM63 N64_63 Vbias3 Vy 0 sky130_fd_pr__nfet_01v8 l=0.245000u w=2.366472u nf=1 ad=1.183236p as=1.183236p pd=4.366472u ps=4.366472u
XM58 N58_57 Vbias2 Vx vdd sky130_fd_pr__pfet_01v8 l=0.340000u w=36.016514u nf=1 ad=18.008257p as=18.008257p pd=38.016514u ps=38.016514u
XM57_p0 Vbias2 Vbias2 N58_57 vdd sky130_fd_pr__pfet_01v8 l=0.340000u w=36.016514u nf=1 ad=18.008257p as=18.008257p pd=38.016514u ps=38.016514u
XM57_p1 Vbias2 Vbias2 N58_57 vdd sky130_fd_pr__pfet_01v8 l=0.340000u w=36.016514u nf=1 ad=18.008257p as=18.008257p pd=38.016514u ps=38.016514u
XM57_p2 Vbias2 Vbias2 N58_57 vdd sky130_fd_pr__pfet_01v8 l=0.340000u w=36.016514u nf=1 ad=18.008257p as=18.008257p pd=38.016514u ps=38.016514u
XM57_p3 Vbias2 Vbias2 N58_57 vdd sky130_fd_pr__pfet_01v8 l=0.340000u w=36.016514u nf=1 ad=18.008257p as=18.008257p pd=38.016514u ps=38.016514u
XM57_p4 Vbias2 Vbias2 N58_57 vdd sky130_fd_pr__pfet_01v8 l=0.340000u w=36.016514u nf=1 ad=18.008257p as=18.008257p pd=38.016514u ps=38.016514u
XM66 Vbias4 Vbias4 0 0 sky130_fd_pr__nfet_01v8 l=0.510911u w=1.219502u nf=1 ad=0.609751p as=0.609751p pd=3.219502u ps=3.219502u
XM68 Vbias2 Vbias4 0 0 sky130_fd_pr__nfet_01v8 l=0.510911u w=1.291251u nf=1 ad=0.645625p as=0.645625p pd=3.291251u ps=3.291251u
XM36a_p0 Vcmfb Vcmfb vdd vdd sky130_fd_pr__pfet_01v8 l=0.473905u w=36.016514u nf=1 ad=18.008257p as=18.008257p pd=38.016514u ps=38.016514u
XM36a_p1 Vcmfb Vcmfb vdd vdd sky130_fd_pr__pfet_01v8 l=0.473905u w=36.016514u nf=1 ad=18.008257p as=18.008257p pd=38.016514u ps=38.016514u
XM36a_p2 Vcmfb Vcmfb vdd vdd sky130_fd_pr__pfet_01v8 l=0.473905u w=36.016514u nf=1 ad=18.008257p as=18.008257p pd=38.016514u ps=38.016514u
XM36a_p3 Vcmfb Vcmfb vdd vdd sky130_fd_pr__pfet_01v8 l=0.473905u w=36.016514u nf=1 ad=18.008257p as=18.008257p pd=38.016514u ps=38.016514u
XM36a_p4 Vcmfb Vcmfb vdd vdd sky130_fd_pr__pfet_01v8 l=0.473905u w=36.016514u nf=1 ad=18.008257p as=18.008257p pd=38.016514u ps=38.016514u
XM36b_p0 N36b N36b vdd vdd sky130_fd_pr__pfet_01v8 l=0.473905u w=36.016514u nf=1 ad=18.008257p as=18.008257p pd=38.016514u ps=38.016514u
XM36b_p1 N36b N36b vdd vdd sky130_fd_pr__pfet_01v8 l=0.473905u w=36.016514u nf=1 ad=18.008257p as=18.008257p pd=38.016514u ps=38.016514u
XM36b_p2 N36b N36b vdd vdd sky130_fd_pr__pfet_01v8 l=0.473905u w=36.016514u nf=1 ad=18.008257p as=18.008257p pd=38.016514u ps=38.016514u
XM36b_p3 N36b N36b vdd vdd sky130_fd_pr__pfet_01v8 l=0.473905u w=36.016514u nf=1 ad=18.008257p as=18.008257p pd=38.016514u ps=38.016514u
XM36b_p4 N36b N36b vdd vdd sky130_fd_pr__pfet_01v8 l=0.473905u w=36.016514u nf=1 ad=18.008257p as=18.008257p pd=38.016514u ps=38.016514u
XM37a Vcmfb Voc Ncmfb_tail 0 sky130_fd_pr__nfet_01v8 l=0.350000u w=36.016514u nf=1 ad=18.008257p as=18.008257p pd=38.016514u ps=38.016514u
XM37b N36b Voc_des Ncmfb_tail 0 sky130_fd_pr__nfet_01v8 l=0.350000u w=36.016514u nf=1 ad=18.008257p as=18.008257p pd=38.016514u ps=38.016514u
XM38_p0 Ncmfb_tail Vbias4 0 0 sky130_fd_pr__nfet_01v8 l=0.510911u w=36.016514u nf=1 ad=18.008257p as=18.008257p pd=38.016514u ps=38.016514u
XM38_p1 Ncmfb_tail Vbias4 0 0 sky130_fd_pr__nfet_01v8 l=0.510911u w=36.016514u nf=1 ad=18.008257p as=18.008257p pd=38.016514u ps=38.016514u
XM38_p2 Ncmfb_tail Vbias4 0 0 sky130_fd_pr__nfet_01v8 l=0.510911u w=36.016514u nf=1 ad=18.008257p as=18.008257p pd=38.016514u ps=38.016514u
XM39_p0 Voc_des Voc_des vdd vdd sky130_fd_pr__pfet_01v8 l=0.340000u w=4.548854u nf=1 ad=2.274427p as=2.274427p pd=6.548854u ps=6.548854u
XM39_p1 Voc_des Voc_des vdd vdd sky130_fd_pr__pfet_01v8 l=0.340000u w=4.548854u nf=1 ad=2.274427p as=2.274427p pd=6.548854u ps=6.548854u
XM40 0 0 Voc_des vdd sky130_fd_pr__pfet_01v8 l=0.340000u w=4.548854u nf=1 ad=2.274427p as=2.274427p pd=6.548854u ps=6.548854u
IIref Vbias1 0 DC 1.992901379193441e-07
RR1 Vom Voc 1000000000.0
RR2 Voc Vop 1000000000.0
CCc1 Vom N_cc_rz1 5e-13
RRz1 N_cc_rz1 Vop1 2118.5226433573807
CCc2 Vop N_cc_rz2 5e-13
RRz2 N_cc_rz2 Vom1 2118.5226433573807
CCL1 Vop 0 1e-12
CCL2 Vom 0 1e-12
CCf1 Vom Vip 5e-13
CCf2 Vop Vim 5e-13
CCs1 Vip 0 5e-13
CCs2 Vim 0 5e-13
Efb_Vip fbs_Vip 0 Vom Vop 0.5
Vofs_Vip fbs_Vip fbd_Vip DC -0.6381178828477307
Lfb_Vip fbd_Vip Vip 1000000000000.0
Cac_Vip Vip acs_Vip 1.0
Vac_Vip acs_Vip 0 DC 0 AC 0.5
Efb_Vim fbs_Vim 0 Vop Vom 0.5
Vofs_Vim fbs_Vim fbd_Vim DC -0.6381178828477307
Lfb_Vim fbd_Vim Vim 1000000000000.0
Cac_Vim Vim acs_Vim 1.0
Vac_Vim acs_Vim 0 DC 0 AC -0.5
.nodeset v(N11a11b)=1.125000 v(N11b)=0.300000 v(N14a14b)=1.237500 v(N14a_14b)=0.562500 v(N1a2a)=0.877278 v(N1b2b)=0.877278 v(N20a20b)=1.125000 v(N20b)=0.300000
.nodeset v(N23a24b)=0.562500 v(N24b23a)=1.237500 v(N36b)=0.937500 v(N3a4a)=0.477278 v(N3b4b)=0.477278 v(N58_57)=1.100000 v(N64_63)=0.589778 v(Ncmfb_tail)=0.737500
.nodeset v(Vbias1)=0.937500 v(Vbias2)=0.312500 v(Vbias3)=1.487500 v(Vbias4)=0.562500 v(Vcmfb)=0.937500 v(Vg15)=0.975032 v(Vg25)=0.975032 v(Vim)=0.638118
.nodeset v(Vip)=0.638118 v(Voc)=1.558775 v(Voc_des)=1.012500 v(Vom)=0.900000 v(Vom1)=0.677278 v(Vop)=0.900000 v(Vop1)=0.677278 v(Vx)=1.550000
.nodeset v(Vy)=0.027278
.control
set noaskquit
op
echo OPSTART
print @m.xm6_p0.msky130_fd_pr__pfet_01v8[id]
print @m.xm6_p0.msky130_fd_pr__pfet_01v8[gm]
print @m.xm6_p0.msky130_fd_pr__pfet_01v8[gds]
print @m.xm6_p0.msky130_fd_pr__pfet_01v8[vth]
print @m.xm6_p0.msky130_fd_pr__pfet_01v8[vdsat]
print @m.xm6_p0.msky130_fd_pr__pfet_01v8[vgs]
print @m.xm6_p0.msky130_fd_pr__pfet_01v8[vds]
print @m.xm6_p0.msky130_fd_pr__pfet_01v8[vbs]
print @m.xm7_p0.msky130_fd_pr__pfet_01v8[id]
print @m.xm7_p0.msky130_fd_pr__pfet_01v8[gm]
print @m.xm7_p0.msky130_fd_pr__pfet_01v8[gds]
print @m.xm7_p0.msky130_fd_pr__pfet_01v8[vth]
print @m.xm7_p0.msky130_fd_pr__pfet_01v8[vdsat]
print @m.xm7_p0.msky130_fd_pr__pfet_01v8[vgs]
print @m.xm7_p0.msky130_fd_pr__pfet_01v8[vds]
print @m.xm7_p0.msky130_fd_pr__pfet_01v8[vbs]
print @m.xm1a_p0.msky130_fd_pr__pfet_01v8[id]
print @m.xm1a_p0.msky130_fd_pr__pfet_01v8[gm]
print @m.xm1a_p0.msky130_fd_pr__pfet_01v8[gds]
print @m.xm1a_p0.msky130_fd_pr__pfet_01v8[vth]
print @m.xm1a_p0.msky130_fd_pr__pfet_01v8[vdsat]
print @m.xm1a_p0.msky130_fd_pr__pfet_01v8[vgs]
print @m.xm1a_p0.msky130_fd_pr__pfet_01v8[vds]
print @m.xm1a_p0.msky130_fd_pr__pfet_01v8[vbs]
print @m.xm1b_p0.msky130_fd_pr__pfet_01v8[id]
print @m.xm1b_p0.msky130_fd_pr__pfet_01v8[gm]
print @m.xm1b_p0.msky130_fd_pr__pfet_01v8[gds]
print @m.xm1b_p0.msky130_fd_pr__pfet_01v8[vth]
print @m.xm1b_p0.msky130_fd_pr__pfet_01v8[vdsat]
print @m.xm1b_p0.msky130_fd_pr__pfet_01v8[vgs]
print @m.xm1b_p0.msky130_fd_pr__pfet_01v8[vds]
print @m.xm1b_p0.msky130_fd_pr__pfet_01v8[vbs]
print @m.xm2a_p0.msky130_fd_pr__pfet_01v8[id]
print @m.xm2a_p0.msky130_fd_pr__pfet_01v8[gm]
print @m.xm2a_p0.msky130_fd_pr__pfet_01v8[gds]
print @m.xm2a_p0.msky130_fd_pr__pfet_01v8[vth]
print @m.xm2a_p0.msky130_fd_pr__pfet_01v8[vdsat]
print @m.xm2a_p0.msky130_fd_pr__pfet_01v8[vgs]
print @m.xm2a_p0.msky130_fd_pr__pfet_01v8[vds]
print @m.xm2a_p0.msky130_fd_pr__pfet_01v8[vbs]
print @m.xm2b_p0.msky130_fd_pr__pfet_01v8[id]
print @m.xm2b_p0.msky130_fd_pr__pfet_01v8[gm]
print @m.xm2b_p0.msky130_fd_pr__pfet_01v8[gds]
print @m.xm2b_p0.msky130_fd_pr__pfet_01v8[vth]
print @m.xm2b_p0.msky130_fd_pr__pfet_01v8[vdsat]
print @m.xm2b_p0.msky130_fd_pr__pfet_01v8[vgs]
print @m.xm2b_p0.msky130_fd_pr__pfet_01v8[vds]
print @m.xm2b_p0.msky130_fd_pr__pfet_01v8[vbs]
print @m.xm3a.msky130_fd_pr__nfet_01v8[id]
print @m.xm3a.msky130_fd_pr__nfet_01v8[gm]
print @m.xm3a.msky130_fd_pr__nfet_01v8[gds]
print @m.xm3a.msky130_fd_pr__nfet_01v8[vth]
print @m.xm3a.msky130_fd_pr__nfet_01v8[vdsat]
print @m.xm3a.msky130_fd_pr__nfet_01v8[vgs]
print @m.xm3a.msky130_fd_pr__nfet_01v8[vds]
print @m.xm3a.msky130_fd_pr__nfet_01v8[vbs]
print @m.xm3b.msky130_fd_pr__nfet_01v8[id]
print @m.xm3b.msky130_fd_pr__nfet_01v8[gm]
print @m.xm3b.msky130_fd_pr__nfet_01v8[gds]
print @m.xm3b.msky130_fd_pr__nfet_01v8[vth]
print @m.xm3b.msky130_fd_pr__nfet_01v8[vdsat]
print @m.xm3b.msky130_fd_pr__nfet_01v8[vgs]
print @m.xm3b.msky130_fd_pr__nfet_01v8[vds]
print @m.xm3b.msky130_fd_pr__nfet_01v8[vbs]
print @m.xm4a.msky130_fd_pr__nfet_01v8[id]
print @m.xm4a.msky130_fd_pr__nfet_01v8[gm]
print @m.xm4a.msky130_fd_pr__nfet_01v8[gds]
print @m.xm4a.msky130_fd_pr__nfet_01v8[vth]
print @m.xm4a.msky130_fd_pr__nfet_01v8[vdsat]
print @m.xm4a.msky130_fd_pr__nfet_01v8[vgs]
print @m.xm4a.msky130_fd_pr__nfet_01v8[vds]
print @m.xm4a.msky130_fd_pr__nfet_01v8[vbs]
print @m.xm4b.msky130_fd_pr__nfet_01v8[id]
print @m.xm4b.msky130_fd_pr__nfet_01v8[gm]
print @m.xm4b.msky130_fd_pr__nfet_01v8[gds]
print @m.xm4b.msky130_fd_pr__nfet_01v8[vth]
print @m.xm4b.msky130_fd_pr__nfet_01v8[vdsat]
print @m.xm4b.msky130_fd_pr__nfet_01v8[vgs]
print @m.xm4b.msky130_fd_pr__nfet_01v8[vds]
print @m.xm4b.msky130_fd_pr__nfet_01v8[vbs]
print @m.xm5_p0.msky130_fd_pr__nfet_01v8[id]
print @m.xm5_p0.msky130_fd_pr__nfet_01v8[gm]
print @m.xm5_p0.msky130_fd_pr__nfet_01v8[gds]
print @m.xm5_p0.msky130_fd_pr__nfet_01v8[vth]
print @m.xm5_p0.msky130_fd_pr__nfet_01v8[vdsat]
print @m.xm5_p0.msky130_fd_pr__nfet_01v8[vgs]
print @m.xm5_p0.msky130_fd_pr__nfet_01v8[vds]
print @m.xm5_p0.msky130_fd_pr__nfet_01v8[vbs]
print @m.xm8_p0.msky130_fd_pr__pfet_01v8[id]
print @m.xm8_p0.msky130_fd_pr__pfet_01v8[gm]
print @m.xm8_p0.msky130_fd_pr__pfet_01v8[gds]
print @m.xm8_p0.msky130_fd_pr__pfet_01v8[vth]
print @m.xm8_p0.msky130_fd_pr__pfet_01v8[vdsat]
print @m.xm8_p0.msky130_fd_pr__pfet_01v8[vgs]
print @m.xm8_p0.msky130_fd_pr__pfet_01v8[vds]
print @m.xm8_p0.msky130_fd_pr__pfet_01v8[vbs]
print @m.xm11a.msky130_fd_pr__pfet_01v8[id]
print @m.xm11a.msky130_fd_pr__pfet_01v8[gm]
print @m.xm11a.msky130_fd_pr__pfet_01v8[gds]
print @m.xm11a.msky130_fd_pr__pfet_01v8[vth]
print @m.xm11a.msky130_fd_pr__pfet_01v8[vdsat]
print @m.xm11a.msky130_fd_pr__pfet_01v8[vgs]
print @m.xm11a.msky130_fd_pr__pfet_01v8[vds]
print @m.xm11a.msky130_fd_pr__pfet_01v8[vbs]
print @m.xm11b_p0.msky130_fd_pr__pfet_01v8[id]
print @m.xm11b_p0.msky130_fd_pr__pfet_01v8[gm]
print @m.xm11b_p0.msky130_fd_pr__pfet_01v8[gds]
print @m.xm11b_p0.msky130_fd_pr__pfet_01v8[vth]
print @m.xm11b_p0.msky130_fd_pr__pfet_01v8[vdsat]
print @m.xm11b_p0.msky130_fd_pr__pfet_01v8[vgs]
print @m.xm11b_p0.msky130_fd_pr__pfet_01v8[vds]
print @m.xm11b_p0.msky130_fd_pr__pfet_01v8[vbs]
print @m.xm15_p0.msky130_fd_pr__pfet_01v8[id]
print @m.xm15_p0.msky130_fd_pr__pfet_01v8[gm]
print @m.xm15_p0.msky130_fd_pr__pfet_01v8[gds]
print @m.xm15_p0.msky130_fd_pr__pfet_01v8[vth]
print @m.xm15_p0.msky130_fd_pr__pfet_01v8[vdsat]
print @m.xm15_p0.msky130_fd_pr__pfet_01v8[vgs]
print @m.xm15_p0.msky130_fd_pr__pfet_01v8[vds]
print @m.xm15_p0.msky130_fd_pr__pfet_01v8[vbs]
print @m.xm9a_p0.msky130_fd_pr__pfet_01v8[id]
print @m.xm9a_p0.msky130_fd_pr__pfet_01v8[gm]
print @m.xm9a_p0.msky130_fd_pr__pfet_01v8[gds]
print @m.xm9a_p0.msky130_fd_pr__pfet_01v8[vth]
print @m.xm9a_p0.msky130_fd_pr__pfet_01v8[vdsat]
print @m.xm9a_p0.msky130_fd_pr__pfet_01v8[vgs]
print @m.xm9a_p0.msky130_fd_pr__pfet_01v8[vds]
print @m.xm9a_p0.msky130_fd_pr__pfet_01v8[vbs]
print @m.xm9b.msky130_fd_pr__nfet_01v8[id]
print @m.xm9b.msky130_fd_pr__nfet_01v8[gm]
print @m.xm9b.msky130_fd_pr__nfet_01v8[gds]
print @m.xm9b.msky130_fd_pr__nfet_01v8[vth]
print @m.xm9b.msky130_fd_pr__nfet_01v8[vdsat]
print @m.xm9b.msky130_fd_pr__nfet_01v8[vgs]
print @m.xm9b.msky130_fd_pr__nfet_01v8[vds]
print @m.xm9b.msky130_fd_pr__nfet_01v8[vbs]
print @m.xm12.msky130_fd_pr__nfet_01v8[id]
print @m.xm12.msky130_fd_pr__nfet_01v8[gm]
print @m.xm12.msky130_fd_pr__nfet_01v8[gds]
print @m.xm12.msky130_fd_pr__nfet_01v8[vth]
print @m.xm12.msky130_fd_pr__nfet_01v8[vdsat]
print @m.xm12.msky130_fd_pr__nfet_01v8[vgs]
print @m.xm12.msky130_fd_pr__nfet_01v8[vds]
print @m.xm12.msky130_fd_pr__nfet_01v8[vbs]
print @m.xm10.msky130_fd_pr__nfet_01v8[id]
print @m.xm10.msky130_fd_pr__nfet_01v8[gm]
print @m.xm10.msky130_fd_pr__nfet_01v8[gds]
print @m.xm10.msky130_fd_pr__nfet_01v8[vth]
print @m.xm10.msky130_fd_pr__nfet_01v8[vdsat]
print @m.xm10.msky130_fd_pr__nfet_01v8[vgs]
print @m.xm10.msky130_fd_pr__nfet_01v8[vds]
print @m.xm10.msky130_fd_pr__nfet_01v8[vbs]
print @m.xm14a.msky130_fd_pr__nfet_01v8[id]
print @m.xm14a.msky130_fd_pr__nfet_01v8[gm]
print @m.xm14a.msky130_fd_pr__nfet_01v8[gds]
print @m.xm14a.msky130_fd_pr__nfet_01v8[vth]
print @m.xm14a.msky130_fd_pr__nfet_01v8[vdsat]
print @m.xm14a.msky130_fd_pr__nfet_01v8[vgs]
print @m.xm14a.msky130_fd_pr__nfet_01v8[vds]
print @m.xm14a.msky130_fd_pr__nfet_01v8[vbs]
print @m.xm14b.msky130_fd_pr__nfet_01v8[id]
print @m.xm14b.msky130_fd_pr__nfet_01v8[gm]
print @m.xm14b.msky130_fd_pr__nfet_01v8[gds]
print @m.xm14b.msky130_fd_pr__nfet_01v8[vth]
print @m.xm14b.msky130_fd_pr__nfet_01v8[vdsat]
print @m.xm14b.msky130_fd_pr__nfet_01v8[vgs]
print @m.xm14b.msky130_fd_pr__nfet_01v8[vds]
print @m.xm14b.msky130_fd_pr__nfet_01v8[vbs]
print @m.xm16_p0.msky130_fd_pr__nfet_01v8[id]
print @m.xm16_p0.msky130_fd_pr__nfet_01v8[gm]
print @m.xm16_p0.msky130_fd_pr__nfet_01v8[gds]
print @m.xm16_p0.msky130_fd_pr__nfet_01v8[vth]
print @m.xm16_p0.msky130_fd_pr__nfet_01v8[vdsat]
print @m.xm16_p0.msky130_fd_pr__nfet_01v8[vgs]
print @m.xm16_p0.msky130_fd_pr__nfet_01v8[vds]
print @m.xm16_p0.msky130_fd_pr__nfet_01v8[vbs]
print @m.xm13_p0.msky130_fd_pr__pfet_01v8[id]
print @m.xm13_p0.msky130_fd_pr__pfet_01v8[gm]
print @m.xm13_p0.msky130_fd_pr__pfet_01v8[gds]
print @m.xm13_p0.msky130_fd_pr__pfet_01v8[vth]
print @m.xm13_p0.msky130_fd_pr__pfet_01v8[vdsat]
print @m.xm13_p0.msky130_fd_pr__pfet_01v8[vgs]
print @m.xm13_p0.msky130_fd_pr__pfet_01v8[vds]
print @m.xm13_p0.msky130_fd_pr__pfet_01v8[vbs]
print @m.xm22_p0.msky130_fd_pr__pfet_01v8[id]
print @m.xm22_p0.msky130_fd_pr__pfet_01v8[gm]
print @m.xm22_p0.msky130_fd_pr__pfet_01v8[gds]
print @m.xm22_p0.msky130_fd_pr__pfet_01v8[vth]
print @m.xm22_p0.msky130_fd_pr__pfet_01v8[vdsat]
print @m.xm22_p0.msky130_fd_pr__pfet_01v8[vgs]
print @m.xm22_p0.msky130_fd_pr__pfet_01v8[vds]
print @m.xm22_p0.msky130_fd_pr__pfet_01v8[vbs]
print @m.xm20a.msky130_fd_pr__pfet_01v8[id]
print @m.xm20a.msky130_fd_pr__pfet_01v8[gm]
print @m.xm20a.msky130_fd_pr__pfet_01v8[gds]
print @m.xm20a.msky130_fd_pr__pfet_01v8[vth]
print @m.xm20a.msky130_fd_pr__pfet_01v8[vdsat]
print @m.xm20a.msky130_fd_pr__pfet_01v8[vgs]
print @m.xm20a.msky130_fd_pr__pfet_01v8[vds]
print @m.xm20a.msky130_fd_pr__pfet_01v8[vbs]
print @m.xm20b_p0.msky130_fd_pr__pfet_01v8[id]
print @m.xm20b_p0.msky130_fd_pr__pfet_01v8[gm]
print @m.xm20b_p0.msky130_fd_pr__pfet_01v8[gds]
print @m.xm20b_p0.msky130_fd_pr__pfet_01v8[vth]
print @m.xm20b_p0.msky130_fd_pr__pfet_01v8[vdsat]
print @m.xm20b_p0.msky130_fd_pr__pfet_01v8[vgs]
print @m.xm20b_p0.msky130_fd_pr__pfet_01v8[vds]
print @m.xm20b_p0.msky130_fd_pr__pfet_01v8[vbs]
print @m.xm25_p0.msky130_fd_pr__pfet_01v8[id]
print @m.xm25_p0.msky130_fd_pr__pfet_01v8[gm]
print @m.xm25_p0.msky130_fd_pr__pfet_01v8[gds]
print @m.xm25_p0.msky130_fd_pr__pfet_01v8[vth]
print @m.xm25_p0.msky130_fd_pr__pfet_01v8[vdsat]
print @m.xm25_p0.msky130_fd_pr__pfet_01v8[vgs]
print @m.xm25_p0.msky130_fd_pr__pfet_01v8[vds]
print @m.xm25_p0.msky130_fd_pr__pfet_01v8[vbs]
print @m.xm18a_p0.msky130_fd_pr__pfet_01v8[id]
print @m.xm18a_p0.msky130_fd_pr__pfet_01v8[gm]
print @m.xm18a_p0.msky130_fd_pr__pfet_01v8[gds]
print @m.xm18a_p0.msky130_fd_pr__pfet_01v8[vth]
print @m.xm18a_p0.msky130_fd_pr__pfet_01v8[vdsat]
print @m.xm18a_p0.msky130_fd_pr__pfet_01v8[vgs]
print @m.xm18a_p0.msky130_fd_pr__pfet_01v8[vds]
print @m.xm18a_p0.msky130_fd_pr__pfet_01v8[vbs]
print @m.xm18b.msky130_fd_pr__nfet_01v8[id]
print @m.xm18b.msky130_fd_pr__nfet_01v8[gm]
print @m.xm18b.msky130_fd_pr__nfet_01v8[gds]
print @m.xm18b.msky130_fd_pr__nfet_01v8[vth]
print @m.xm18b.msky130_fd_pr__nfet_01v8[vdsat]
print @m.xm18b.msky130_fd_pr__nfet_01v8[vgs]
print @m.xm18b.msky130_fd_pr__nfet_01v8[vds]
print @m.xm18b.msky130_fd_pr__nfet_01v8[vbs]
print @m.xm21.msky130_fd_pr__nfet_01v8[id]
print @m.xm21.msky130_fd_pr__nfet_01v8[gm]
print @m.xm21.msky130_fd_pr__nfet_01v8[gds]
print @m.xm21.msky130_fd_pr__nfet_01v8[vth]
print @m.xm21.msky130_fd_pr__nfet_01v8[vdsat]
print @m.xm21.msky130_fd_pr__nfet_01v8[vgs]
print @m.xm21.msky130_fd_pr__nfet_01v8[vds]
print @m.xm21.msky130_fd_pr__nfet_01v8[vbs]
print @m.xm19.msky130_fd_pr__nfet_01v8[id]
print @m.xm19.msky130_fd_pr__nfet_01v8[gm]
print @m.xm19.msky130_fd_pr__nfet_01v8[gds]
print @m.xm19.msky130_fd_pr__nfet_01v8[vth]
print @m.xm19.msky130_fd_pr__nfet_01v8[vdsat]
print @m.xm19.msky130_fd_pr__nfet_01v8[vgs]
print @m.xm19.msky130_fd_pr__nfet_01v8[vds]
print @m.xm19.msky130_fd_pr__nfet_01v8[vbs]
print @m.xm23a.msky130_fd_pr__nfet_01v8[id]
print @m.xm23a.msky130_fd_pr__nfet_01v8[gm]
print @m.xm23a.msky130_fd_pr__nfet_01v8[gds]
print @m.xm23a.msky130_fd_pr__nfet_01v8[vth]
print @m.xm23a.msky130_fd_pr__nfet_01v8[vdsat]
print @m.xm23a.msky130_fd_pr__nfet_01v8[vgs]
print @m.xm23a.msky130_fd_pr__nfet_01v8[vds]
print @m.xm23a.msky130_fd_pr__nfet_01v8[vbs]
print @m.xm24b.msky130_fd_pr__nfet_01v8[id]
print @m.xm24b.msky130_fd_pr__nfet_01v8[gm]
print @m.xm24b.msky130_fd_pr__nfet_01v8[gds]
print @m.xm24b.msky130_fd_pr__nfet_01v8[vth]
print @m.xm24b.msky130_fd_pr__nfet_01v8[vdsat]
print @m.xm24b.msky130_fd_pr__nfet_01v8[vgs]
print @m.xm24b.msky130_fd_pr__nfet_01v8[vds]
print @m.xm24b.msky130_fd_pr__nfet_01v8[vbs]
print @m.xm26_p0.msky130_fd_pr__nfet_01v8[id]
print @m.xm26_p0.msky130_fd_pr__nfet_01v8[gm]
print @m.xm26_p0.msky130_fd_pr__nfet_01v8[gds]
print @m.xm26_p0.msky130_fd_pr__nfet_01v8[vth]
print @m.xm26_p0.msky130_fd_pr__nfet_01v8[vdsat]
print @m.xm26_p0.msky130_fd_pr__nfet_01v8[vgs]
print @m.xm26_p0.msky130_fd_pr__nfet_01v8[vds]
print @m.xm26_p0.msky130_fd_pr__nfet_01v8[vbs]
print @m.xm17_p0.msky130_fd_pr__pfet_01v8[id]
print @m.xm17_p0.msky130_fd_pr__pfet_01v8[gm]
print @m.xm17_p0.msky130_fd_pr__pfet_01v8[gds]
print @m.xm17_p0.msky130_fd_pr__pfet_01v8[vth]
print @m.xm17_p0.msky130_fd_pr__pfet_01v8[vdsat]
print @m.xm17_p0.msky130_fd_pr__pfet_01v8[vgs]
print @m.xm17_p0.msky130_fd_pr__pfet_01v8[vds]
print @m.xm17_p0.msky130_fd_pr__pfet_01v8[vbs]
print @m.xm18_bg.msky130_fd_pr__pfet_01v8[id]
print @m.xm18_bg.msky130_fd_pr__pfet_01v8[gm]
print @m.xm18_bg.msky130_fd_pr__pfet_01v8[gds]
print @m.xm18_bg.msky130_fd_pr__pfet_01v8[vth]
print @m.xm18_bg.msky130_fd_pr__pfet_01v8[vdsat]
print @m.xm18_bg.msky130_fd_pr__pfet_01v8[vgs]
print @m.xm18_bg.msky130_fd_pr__pfet_01v8[vds]
print @m.xm18_bg.msky130_fd_pr__pfet_01v8[vbs]
print @m.xm60.msky130_fd_pr__pfet_01v8[id]
print @m.xm60.msky130_fd_pr__pfet_01v8[gm]
print @m.xm60.msky130_fd_pr__pfet_01v8[gds]
print @m.xm60.msky130_fd_pr__pfet_01v8[vth]
print @m.xm60.msky130_fd_pr__pfet_01v8[vdsat]
print @m.xm60.msky130_fd_pr__pfet_01v8[vgs]
print @m.xm60.msky130_fd_pr__pfet_01v8[vds]
print @m.xm60.msky130_fd_pr__pfet_01v8[vbs]
print @m.xm61.msky130_fd_pr__pfet_01v8[id]
print @m.xm61.msky130_fd_pr__pfet_01v8[gm]
print @m.xm61.msky130_fd_pr__pfet_01v8[gds]
print @m.xm61.msky130_fd_pr__pfet_01v8[vth]
print @m.xm61.msky130_fd_pr__pfet_01v8[vdsat]
print @m.xm61.msky130_fd_pr__pfet_01v8[vgs]
print @m.xm61.msky130_fd_pr__pfet_01v8[vds]
print @m.xm61.msky130_fd_pr__pfet_01v8[vbs]
print @m.xm64.msky130_fd_pr__nfet_01v8[id]
print @m.xm64.msky130_fd_pr__nfet_01v8[gm]
print @m.xm64.msky130_fd_pr__nfet_01v8[gds]
print @m.xm64.msky130_fd_pr__nfet_01v8[vth]
print @m.xm64.msky130_fd_pr__nfet_01v8[vdsat]
print @m.xm64.msky130_fd_pr__nfet_01v8[vgs]
print @m.xm64.msky130_fd_pr__nfet_01v8[vds]
print @m.xm64.msky130_fd_pr__nfet_01v8[vbs]
print @m.xm63.msky130_fd_pr__nfet_01v8[id]
print @m.xm63.msky130_fd_pr__nfet_01v8[gm]
print @m.xm63.msky130_fd_pr__nfet_01v8[gds]
print @m.xm63.msky130_fd_pr__nfet_01v8[vth]
print @m.xm63.msky130_fd_pr__nfet_01v8[vdsat]
print @m.xm63.msky130_fd_pr__nfet_01v8[vgs]
print @m.xm63.msky130_fd_pr__nfet_01v8[vds]
print @m.xm63.msky130_fd_pr__nfet_01v8[vbs]
print @m.xm58.msky130_fd_pr__pfet_01v8[id]
print @m.xm58.msky130_fd_pr__pfet_01v8[gm]
print @m.xm58.msky130_fd_pr__pfet_01v8[gds]
print @m.xm58.msky130_fd_pr__pfet_01v8[vth]
print @m.xm58.msky130_fd_pr__pfet_01v8[vdsat]
print @m.xm58.msky130_fd_pr__pfet_01v8[vgs]
print @m.xm58.msky130_fd_pr__pfet_01v8[vds]
print @m.xm58.msky130_fd_pr__pfet_01v8[vbs]
print @m.xm57_p0.msky130_fd_pr__pfet_01v8[id]
print @m.xm57_p0.msky130_fd_pr__pfet_01v8[gm]
print @m.xm57_p0.msky130_fd_pr__pfet_01v8[gds]
print @m.xm57_p0.msky130_fd_pr__pfet_01v8[vth]
print @m.xm57_p0.msky130_fd_pr__pfet_01v8[vdsat]
print @m.xm57_p0.msky130_fd_pr__pfet_01v8[vgs]
print @m.xm57_p0.msky130_fd_pr__pfet_01v8[vds]
print @m.xm57_p0.msky130_fd_pr__pfet_01v8[vbs]
print @m.xm66.msky130_fd_pr__nfet_01v8[id]
print @m.xm66.msky130_fd_pr__nfet_01v8[gm]
print @m.xm66.msky130_fd_pr__nfet_01v8[gds]
print @m.xm66.msky130_fd_pr__nfet_01v8[vth]
print @m.xm66.msky130_fd_pr__nfet_01v8[vdsat]
print @m.xm66.msky130_fd_pr__nfet_01v8[vgs]
print @m.xm66.msky130_fd_pr__nfet_01v8[vds]
print @m.xm66.msky130_fd_pr__nfet_01v8[vbs]
print @m.xm68.msky130_fd_pr__nfet_01v8[id]
print @m.xm68.msky130_fd_pr__nfet_01v8[gm]
print @m.xm68.msky130_fd_pr__nfet_01v8[gds]
print @m.xm68.msky130_fd_pr__nfet_01v8[vth]
print @m.xm68.msky130_fd_pr__nfet_01v8[vdsat]
print @m.xm68.msky130_fd_pr__nfet_01v8[vgs]
print @m.xm68.msky130_fd_pr__nfet_01v8[vds]
print @m.xm68.msky130_fd_pr__nfet_01v8[vbs]
print @m.xm36a_p0.msky130_fd_pr__pfet_01v8[id]
print @m.xm36a_p0.msky130_fd_pr__pfet_01v8[gm]
print @m.xm36a_p0.msky130_fd_pr__pfet_01v8[gds]
print @m.xm36a_p0.msky130_fd_pr__pfet_01v8[vth]
print @m.xm36a_p0.msky130_fd_pr__pfet_01v8[vdsat]
print @m.xm36a_p0.msky130_fd_pr__pfet_01v8[vgs]
print @m.xm36a_p0.msky130_fd_pr__pfet_01v8[vds]
print @m.xm36a_p0.msky130_fd_pr__pfet_01v8[vbs]
print @m.xm36b_p0.msky130_fd_pr__pfet_01v8[id]
print @m.xm36b_p0.msky130_fd_pr__pfet_01v8[gm]
print @m.xm36b_p0.msky130_fd_pr__pfet_01v8[gds]
print @m.xm36b_p0.msky130_fd_pr__pfet_01v8[vth]
print @m.xm36b_p0.msky130_fd_pr__pfet_01v8[vdsat]
print @m.xm36b_p0.msky130_fd_pr__pfet_01v8[vgs]
print @m.xm36b_p0.msky130_fd_pr__pfet_01v8[vds]
print @m.xm36b_p0.msky130_fd_pr__pfet_01v8[vbs]
print @m.xm37a.msky130_fd_pr__nfet_01v8[id]
print @m.xm37a.msky130_fd_pr__nfet_01v8[gm]
print @m.xm37a.msky130_fd_pr__nfet_01v8[gds]
print @m.xm37a.msky130_fd_pr__nfet_01v8[vth]
print @m.xm37a.msky130_fd_pr__nfet_01v8[vdsat]
print @m.xm37a.msky130_fd_pr__nfet_01v8[vgs]
print @m.xm37a.msky130_fd_pr__nfet_01v8[vds]
print @m.xm37a.msky130_fd_pr__nfet_01v8[vbs]
print @m.xm37b.msky130_fd_pr__nfet_01v8[id]
print @m.xm37b.msky130_fd_pr__nfet_01v8[gm]
print @m.xm37b.msky130_fd_pr__nfet_01v8[gds]
print @m.xm37b.msky130_fd_pr__nfet_01v8[vth]
print @m.xm37b.msky130_fd_pr__nfet_01v8[vdsat]
print @m.xm37b.msky130_fd_pr__nfet_01v8[vgs]
print @m.xm37b.msky130_fd_pr__nfet_01v8[vds]
print @m.xm37b.msky130_fd_pr__nfet_01v8[vbs]
print @m.xm38_p0.msky130_fd_pr__nfet_01v8[id]
print @m.xm38_p0.msky130_fd_pr__nfet_01v8[gm]
print @m.xm38_p0.msky130_fd_pr__nfet_01v8[gds]
print @m.xm38_p0.msky130_fd_pr__nfet_01v8[vth]
print @m.xm38_p0.msky130_fd_pr__nfet_01v8[vdsat]
print @m.xm38_p0.msky130_fd_pr__nfet_01v8[vgs]
print @m.xm38_p0.msky130_fd_pr__nfet_01v8[vds]
print @m.xm38_p0.msky130_fd_pr__nfet_01v8[vbs]
print @m.xm39_p0.msky130_fd_pr__pfet_01v8[id]
print @m.xm39_p0.msky130_fd_pr__pfet_01v8[gm]
print @m.xm39_p0.msky130_fd_pr__pfet_01v8[gds]
print @m.xm39_p0.msky130_fd_pr__pfet_01v8[vth]
print @m.xm39_p0.msky130_fd_pr__pfet_01v8[vdsat]
print @m.xm39_p0.msky130_fd_pr__pfet_01v8[vgs]
print @m.xm39_p0.msky130_fd_pr__pfet_01v8[vds]
print @m.xm39_p0.msky130_fd_pr__pfet_01v8[vbs]
print @m.xm40.msky130_fd_pr__pfet_01v8[id]
print @m.xm40.msky130_fd_pr__pfet_01v8[gm]
print @m.xm40.msky130_fd_pr__pfet_01v8[gds]
print @m.xm40.msky130_fd_pr__pfet_01v8[vth]
print @m.xm40.msky130_fd_pr__pfet_01v8[vdsat]
print @m.xm40.msky130_fd_pr__pfet_01v8[vgs]
print @m.xm40.msky130_fd_pr__pfet_01v8[vds]
print @m.xm40.msky130_fd_pr__pfet_01v8[vbs]
print v(N11a11b)
print v(N11b)
print v(N14a14b)
print v(N14a_14b)
print v(N1a2a)
print v(N1b2b)
print v(N20a20b)
print v(N20b)
print v(N23a24b)
print v(N24b23a)
print v(N36b)
print v(N3a4a)
print v(N3b4b)
print v(N58_57)
print v(N64_63)
print v(Ncmfb_tail)
print v(Vbias1)
print v(Vbias2)
print v(Vbias3)
print v(Vbias4)
print v(Vcmfb)
print v(Vg15)
print v(Vg25)
print v(Vim)
print v(Vip)
print v(Voc)
print v(Voc_des)
print v(Vom)
print v(Vom1)
print v(Vop)
print v(Vop1)
print v(Vx)
print v(Vy)
print v(vdd)
print i(vvdd)
echo OPEND
ac dec 40 0.01 10000000000.0
let hout = v(Vop) - v(Vom)
set wr_singlescale
wrdata C:/g452/sim/current_reuse_telescopic_ota.eng_iref.ac.txt hout
quit
.endc
.end
