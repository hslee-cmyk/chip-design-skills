* folded_cascode hand design
.include "C:/pdk/sky130_fd_pr/cells/nfet_01v8/sky130_fd_pr__nfet_01v8__tt.pm3.spice"
.include "C:/pdk/sky130_fd_pr/cells/nfet_01v8/sky130_fd_pr__nfet_01v8__mismatch.corner.spice"
.include "C:/pdk/sky130_fd_pr/models/parameters/lod.spice"
.include "C:/pdk/sky130_fd_pr/cells/pfet_01v8/sky130_fd_pr__pfet_01v8__tt.pm3.spice"
.include "C:/pdk/sky130_fd_pr/cells/pfet_01v8/sky130_fd_pr__pfet_01v8__mismatch.corner.spice"
Vdd vdd 0 dc 1.8
RMP_g_0 vb1 MP_g_0 7593.66
XMP_0 vb1 MP_g_0 vdd vdd sky130_fd_pr__pfet_01v8 l=2.5u w=1.65u ad=0.231p as=0.231p pd=0.28u ps=0.28u nf=1
RMP_g_1 vb1 MP_g_1 7593.66
XMP_1 vb1 MP_g_1 vdd vdd sky130_fd_pr__pfet_01v8 l=2.5u w=1.65u ad=0.43725p as=0.231p pd=2.18u ps=0.28u nf=1
RMP_g_2 vb1 MP_g_2 7593.66
XMP_2 vb1 MP_g_2 vdd vdd sky130_fd_pr__pfet_01v8 l=2.5u w=1.65u ad=0.231p as=0.43725p pd=0.28u ps=2.18u nf=1
RMP_g_3 vb1 MP_g_3 7593.66
XMP_3 vb1 MP_g_3 vdd vdd sky130_fd_pr__pfet_01v8 l=2.5u w=1.65u ad=0.231p as=0.231p pd=0.28u ps=0.28u nf=1
RM3_g_0 vb1 M3_g_0 15187.3
XM3_0 X M3_g_0 vdd vdd sky130_fd_pr__pfet_01v8 l=2.5u w=1.65u ad=0.231p as=0.231p pd=0.28u ps=0.28u nf=1
RM3_g_1 vb1 M3_g_1 15187.3
XM3_1 X M3_g_1 vdd vdd sky130_fd_pr__pfet_01v8 l=2.5u w=1.65u ad=0.231p as=0.231p pd=0.28u ps=0.28u nf=1
RM3_g_2 vb1 M3_g_2 15187.3
XM3_2 X M3_g_2 vdd vdd sky130_fd_pr__pfet_01v8 l=2.5u w=1.65u ad=0.231p as=0.231p pd=0.28u ps=0.28u nf=1
RM3_g_3 vb1 M3_g_3 15187.3
XM3_3 X M3_g_3 vdd vdd sky130_fd_pr__pfet_01v8 l=2.5u w=1.65u ad=0.231p as=0.231p pd=0.28u ps=0.28u nf=1
RM3_g_4 vb1 M3_g_4 15187.3
XM3_4 X M3_g_4 vdd vdd sky130_fd_pr__pfet_01v8 l=2.5u w=1.65u ad=0.231p as=0.231p pd=0.28u ps=0.28u nf=1
RM3_g_5 vb1 M3_g_5 15187.3
XM3_5 X M3_g_5 vdd vdd sky130_fd_pr__pfet_01v8 l=2.5u w=1.65u ad=0.231p as=0.231p pd=0.28u ps=0.28u nf=1
RM3_g_6 vb1 M3_g_6 15187.3
XM3_6 X M3_g_6 vdd vdd sky130_fd_pr__pfet_01v8 l=2.5u w=1.65u ad=0.231p as=0.231p pd=0.28u ps=0.28u nf=1
RM3_g_7 vb1 M3_g_7 15187.3
XM3_7 X M3_g_7 vdd vdd sky130_fd_pr__pfet_01v8 l=2.5u w=1.65u ad=0.231p as=0.231p pd=0.28u ps=0.28u nf=1
RM4_g_0 vb1 M4_g_0 15187.3
XM4_0 Y M4_g_0 vdd vdd sky130_fd_pr__pfet_01v8 l=2.5u w=1.65u ad=0.231p as=0.231p pd=0.28u ps=0.28u nf=1
RM4_g_1 vb1 M4_g_1 15187.3
XM4_1 Y M4_g_1 vdd vdd sky130_fd_pr__pfet_01v8 l=2.5u w=1.65u ad=0.231p as=0.231p pd=0.28u ps=0.28u nf=1
RM4_g_2 vb1 M4_g_2 15187.3
XM4_2 Y M4_g_2 vdd vdd sky130_fd_pr__pfet_01v8 l=2.5u w=1.65u ad=0.231p as=0.231p pd=0.28u ps=0.28u nf=1
RM4_g_3 vb1 M4_g_3 15187.3
XM4_3 Y M4_g_3 vdd vdd sky130_fd_pr__pfet_01v8 l=2.5u w=1.65u ad=0.231p as=0.231p pd=0.28u ps=0.28u nf=1
RM4_g_4 vb1 M4_g_4 15187.3
XM4_4 Y M4_g_4 vdd vdd sky130_fd_pr__pfet_01v8 l=2.5u w=1.65u ad=0.231p as=0.231p pd=0.28u ps=0.28u nf=1
RM4_g_5 vb1 M4_g_5 15187.3
XM4_5 Y M4_g_5 vdd vdd sky130_fd_pr__pfet_01v8 l=2.5u w=1.65u ad=0.231p as=0.231p pd=0.28u ps=0.28u nf=1
RM4_g_6 vb1 M4_g_6 15187.3
XM4_6 Y M4_g_6 vdd vdd sky130_fd_pr__pfet_01v8 l=2.5u w=1.65u ad=0.231p as=0.231p pd=0.28u ps=0.28u nf=1
RM4_g_7 vb1 M4_g_7 15187.3
XM4_7 Y M4_g_7 vdd vdd sky130_fd_pr__pfet_01v8 l=2.5u w=1.65u ad=0.231p as=0.231p pd=0.28u ps=0.28u nf=1
RM5_g_0 bias3 M5_g_0 7095.72
XM5_0 Vg7 M5_g_0 Y vdd sky130_fd_pr__pfet_01v8 l=0.35u w=1.65u ad=0.231p as=0.43725p pd=0.28u ps=2.18u nf=1
RM5_g_1 bias3 M5_g_1 7095.72
XM5_1 Vg7 M5_g_1 Y vdd sky130_fd_pr__pfet_01v8 l=0.35u w=1.65u ad=0.231p as=0.231p pd=0.28u ps=0.28u nf=1
RM5_g_2 bias3 M5_g_2 7095.72
XM5_2 Vg7 M5_g_2 Y vdd sky130_fd_pr__pfet_01v8 l=0.35u w=1.65u ad=0.43725p as=0.231p pd=2.18u ps=0.28u nf=1
RM5_g_3 bias3 M5_g_3 7095.72
XM5_3 Vg7 M5_g_3 Y vdd sky130_fd_pr__pfet_01v8 l=0.35u w=1.65u ad=0.231p as=0.43725p pd=0.28u ps=2.18u nf=1
RM5_g_4 bias3 M5_g_4 7095.72
XM5_4 Vg7 M5_g_4 Y vdd sky130_fd_pr__pfet_01v8 l=0.35u w=1.65u ad=0.231p as=0.231p pd=0.28u ps=0.28u nf=1
RM5_g_5 bias3 M5_g_5 7095.72
XM5_5 Vg7 M5_g_5 Y vdd sky130_fd_pr__pfet_01v8 l=0.35u w=1.65u ad=0.43725p as=0.231p pd=2.18u ps=0.28u nf=1
RM6_g_0 bias3 M6_g_0 7095.72
XM6_0 out M6_g_0 X vdd sky130_fd_pr__pfet_01v8 l=0.35u w=1.65u ad=0.231p as=0.43725p pd=0.28u ps=2.18u nf=1
RM6_g_1 bias3 M6_g_1 7095.72
XM6_1 out M6_g_1 X vdd sky130_fd_pr__pfet_01v8 l=0.35u w=1.65u ad=0.231p as=0.231p pd=0.28u ps=0.28u nf=1
RM6_g_2 bias3 M6_g_2 7095.72
XM6_2 out M6_g_2 X vdd sky130_fd_pr__pfet_01v8 l=0.35u w=1.65u ad=0.231p as=0.231p pd=0.28u ps=0.28u nf=1
RM6_g_3 bias3 M6_g_3 7095.72
XM6_3 out M6_g_3 X vdd sky130_fd_pr__pfet_01v8 l=0.35u w=1.65u ad=0.231p as=0.231p pd=0.28u ps=0.28u nf=1
RM6_g_4 bias3 M6_g_4 7095.72
XM6_4 out M6_g_4 X vdd sky130_fd_pr__pfet_01v8 l=0.35u w=1.65u ad=0.231p as=0.231p pd=0.28u ps=0.28u nf=1
RM6_g_5 bias3 M6_g_5 7095.72
XM6_5 out M6_g_5 X vdd sky130_fd_pr__pfet_01v8 l=0.35u w=1.65u ad=0.43725p as=0.231p pd=2.18u ps=0.28u nf=1
RM1_g_0 vin_n M1_g_0 40116.7
XM1_0 X M1_g_0 tail 0 sky130_fd_pr__nfet_01v8 l=0.5u w=0.84u ad=0.1176p as=0.1176p pd=0.28u ps=0.28u nf=1
RM1_g_1 vin_n M1_g_1 40116.7
XM1_1 X M1_g_1 tail 0 sky130_fd_pr__nfet_01v8 l=0.5u w=0.84u ad=0.1176p as=0.1176p pd=0.28u ps=0.28u nf=1
RM1_g_2 vin_n M1_g_2 40116.7
XM1_2 X M1_g_2 tail 0 sky130_fd_pr__nfet_01v8 l=0.5u w=0.84u ad=0.1176p as=0.1176p pd=0.28u ps=0.28u nf=1
RM1_g_3 vin_n M1_g_3 40116.7
XM1_3 X M1_g_3 tail 0 sky130_fd_pr__nfet_01v8 l=0.5u w=0.84u ad=0.1176p as=0.1176p pd=0.28u ps=0.28u nf=1
RM1_g_4 vin_n M1_g_4 40116.7
XM1_4 X M1_g_4 tail 0 sky130_fd_pr__nfet_01v8 l=0.5u w=0.84u ad=0.1176p as=0.1176p pd=0.28u ps=0.28u nf=1
RM1_g_5 vin_n M1_g_5 40116.7
XM1_5 X M1_g_5 tail 0 sky130_fd_pr__nfet_01v8 l=0.5u w=0.84u ad=0.1176p as=0.1176p pd=0.28u ps=0.28u nf=1
RM1_g_6 vin_n M1_g_6 40116.7
XM1_6 X M1_g_6 tail 0 sky130_fd_pr__nfet_01v8 l=0.5u w=0.84u ad=0.1176p as=0.1176p pd=0.28u ps=0.28u nf=1
RM1_g_7 vin_n M1_g_7 40116.7
XM1_7 X M1_g_7 tail 0 sky130_fd_pr__nfet_01v8 l=0.5u w=0.84u ad=0.1176p as=0.1176p pd=0.28u ps=0.28u nf=1
RM1_g_8 vin_n M1_g_8 40116.7
XM1_8 X M1_g_8 tail 0 sky130_fd_pr__nfet_01v8 l=0.5u w=0.84u ad=0.1176p as=0.1176p pd=0.28u ps=0.28u nf=1
RM1_g_9 vin_n M1_g_9 40116.7
XM1_9 X M1_g_9 tail 0 sky130_fd_pr__nfet_01v8 l=0.5u w=0.84u ad=0.1176p as=0.1176p pd=0.28u ps=0.28u nf=1
RM1_g_10 vin_n M1_g_10 40116.7
XM1_10 X M1_g_10 tail 0 sky130_fd_pr__nfet_01v8 l=0.5u w=0.84u ad=0.1176p as=0.1176p pd=0.28u ps=0.28u nf=1
RM1_g_11 vin_n M1_g_11 40116.7
XM1_11 X M1_g_11 tail 0 sky130_fd_pr__nfet_01v8 l=0.5u w=0.84u ad=0.1176p as=0.1176p pd=0.28u ps=0.28u nf=1
RM1_g_12 vin_n M1_g_12 40116.7
XM1_12 X M1_g_12 tail 0 sky130_fd_pr__nfet_01v8 l=0.5u w=0.84u ad=0.1176p as=0.1176p pd=0.28u ps=0.28u nf=1
RM1_g_13 vin_n M1_g_13 40116.7
XM1_13 X M1_g_13 tail 0 sky130_fd_pr__nfet_01v8 l=0.5u w=0.84u ad=0.1176p as=0.1176p pd=0.28u ps=0.28u nf=1
RM1_g_14 vin_n M1_g_14 40116.7
XM1_14 X M1_g_14 tail 0 sky130_fd_pr__nfet_01v8 l=0.5u w=0.84u ad=0.1176p as=0.1176p pd=0.28u ps=0.28u nf=1
RM1_g_15 vin_n M1_g_15 40116.7
XM1_15 X M1_g_15 tail 0 sky130_fd_pr__nfet_01v8 l=0.5u w=0.84u ad=0.1176p as=0.1176p pd=0.28u ps=0.28u nf=1
RM1_g_16 vin_n M1_g_16 40116.7
XM1_16 X M1_g_16 tail 0 sky130_fd_pr__nfet_01v8 l=0.5u w=0.84u ad=0.1176p as=0.1176p pd=0.28u ps=0.28u nf=1
RM1_g_17 vin_n M1_g_17 40116.7
XM1_17 X M1_g_17 tail 0 sky130_fd_pr__nfet_01v8 l=0.5u w=0.84u ad=0.1176p as=0.1176p pd=0.28u ps=0.28u nf=1
RM1_g_18 vin_n M1_g_18 40116.7
XM1_18 X M1_g_18 tail 0 sky130_fd_pr__nfet_01v8 l=0.5u w=0.84u ad=0.1176p as=0.1176p pd=0.28u ps=0.28u nf=1
RM1_g_19 vin_n M1_g_19 40116.7
XM1_19 X M1_g_19 tail 0 sky130_fd_pr__nfet_01v8 l=0.5u w=0.84u ad=0.1176p as=0.1176p pd=0.28u ps=0.28u nf=1
RM1_g_20 vin_n M1_g_20 40116.7
XM1_20 X M1_g_20 tail 0 sky130_fd_pr__nfet_01v8 l=0.5u w=0.84u ad=0.1176p as=0.1176p pd=0.28u ps=0.28u nf=1
RM1_g_21 vin_n M1_g_21 40116.7
XM1_21 X M1_g_21 tail 0 sky130_fd_pr__nfet_01v8 l=0.5u w=0.84u ad=0.1176p as=0.1176p pd=0.28u ps=0.28u nf=1
RM1_g_22 vin_n M1_g_22 40116.7
XM1_22 X M1_g_22 tail 0 sky130_fd_pr__nfet_01v8 l=0.5u w=0.84u ad=0.1176p as=0.1176p pd=0.28u ps=0.28u nf=1
RM1_g_23 vin_n M1_g_23 40116.7
XM1_23 X M1_g_23 tail 0 sky130_fd_pr__nfet_01v8 l=0.5u w=0.84u ad=0.1176p as=0.1176p pd=0.28u ps=0.28u nf=1
RM2_g_0 vin_p M2_g_0 34719.6
XM2_0 Y M2_g_0 tail 0 sky130_fd_pr__nfet_01v8 l=0.5u w=0.84u ad=0.1176p as=0.1176p pd=0.28u ps=0.28u nf=1
RM2_g_1 vin_p M2_g_1 34719.6
XM2_1 Y M2_g_1 tail 0 sky130_fd_pr__nfet_01v8 l=0.5u w=0.84u ad=0.1176p as=0.1176p pd=0.28u ps=0.28u nf=1
RM2_g_2 vin_p M2_g_2 34719.6
XM2_2 Y M2_g_2 tail 0 sky130_fd_pr__nfet_01v8 l=0.5u w=0.84u ad=0.1176p as=0.1176p pd=0.28u ps=0.28u nf=1
RM2_g_3 vin_p M2_g_3 34719.6
XM2_3 Y M2_g_3 tail 0 sky130_fd_pr__nfet_01v8 l=0.5u w=0.84u ad=0.1176p as=0.1176p pd=0.28u ps=0.28u nf=1
RM2_g_4 vin_p M2_g_4 34719.6
XM2_4 Y M2_g_4 tail 0 sky130_fd_pr__nfet_01v8 l=0.5u w=0.84u ad=0.1176p as=0.1176p pd=0.28u ps=0.28u nf=1
RM2_g_5 vin_p M2_g_5 34719.6
XM2_5 Y M2_g_5 tail 0 sky130_fd_pr__nfet_01v8 l=0.5u w=0.84u ad=0.1176p as=0.1176p pd=0.28u ps=0.28u nf=1
RM2_g_6 vin_p M2_g_6 34719.6
XM2_6 Y M2_g_6 tail 0 sky130_fd_pr__nfet_01v8 l=0.5u w=0.84u ad=0.1176p as=0.1176p pd=0.28u ps=0.28u nf=1
RM2_g_7 vin_p M2_g_7 34719.6
XM2_7 Y M2_g_7 tail 0 sky130_fd_pr__nfet_01v8 l=0.5u w=0.84u ad=0.1176p as=0.1176p pd=0.28u ps=0.28u nf=1
RM2_g_8 vin_p M2_g_8 34719.6
XM2_8 Y M2_g_8 tail 0 sky130_fd_pr__nfet_01v8 l=0.5u w=0.84u ad=0.1176p as=0.1176p pd=0.28u ps=0.28u nf=1
RM2_g_9 vin_p M2_g_9 34719.6
XM2_9 Y M2_g_9 tail 0 sky130_fd_pr__nfet_01v8 l=0.5u w=0.84u ad=0.1176p as=0.1176p pd=0.28u ps=0.28u nf=1
RM2_g_10 vin_p M2_g_10 34719.6
XM2_10 Y M2_g_10 tail 0 sky130_fd_pr__nfet_01v8 l=0.5u w=0.84u ad=0.1176p as=0.1176p pd=0.28u ps=0.28u nf=1
RM2_g_11 vin_p M2_g_11 34719.6
XM2_11 Y M2_g_11 tail 0 sky130_fd_pr__nfet_01v8 l=0.5u w=0.84u ad=0.1176p as=0.1176p pd=0.28u ps=0.28u nf=1
RM2_g_12 vin_p M2_g_12 34719.6
XM2_12 Y M2_g_12 tail 0 sky130_fd_pr__nfet_01v8 l=0.5u w=0.84u ad=0.1176p as=0.1176p pd=0.28u ps=0.28u nf=1
RM2_g_13 vin_p M2_g_13 34719.6
XM2_13 Y M2_g_13 tail 0 sky130_fd_pr__nfet_01v8 l=0.5u w=0.84u ad=0.1176p as=0.1176p pd=0.28u ps=0.28u nf=1
RM2_g_14 vin_p M2_g_14 34719.6
XM2_14 Y M2_g_14 tail 0 sky130_fd_pr__nfet_01v8 l=0.5u w=0.84u ad=0.1176p as=0.1176p pd=0.28u ps=0.28u nf=1
RM2_g_15 vin_p M2_g_15 34719.6
XM2_15 Y M2_g_15 tail 0 sky130_fd_pr__nfet_01v8 l=0.5u w=0.84u ad=0.1176p as=0.1176p pd=0.28u ps=0.28u nf=1
RM2_g_16 vin_p M2_g_16 34719.6
XM2_16 Y M2_g_16 tail 0 sky130_fd_pr__nfet_01v8 l=0.5u w=0.84u ad=0.1176p as=0.1176p pd=0.28u ps=0.28u nf=1
RM2_g_17 vin_p M2_g_17 34719.6
XM2_17 Y M2_g_17 tail 0 sky130_fd_pr__nfet_01v8 l=0.5u w=0.84u ad=0.1176p as=0.1176p pd=0.28u ps=0.28u nf=1
RM2_g_18 vin_p M2_g_18 34719.6
XM2_18 Y M2_g_18 tail 0 sky130_fd_pr__nfet_01v8 l=0.5u w=0.84u ad=0.1176p as=0.1176p pd=0.28u ps=0.28u nf=1
RM2_g_19 vin_p M2_g_19 34719.6
XM2_19 Y M2_g_19 tail 0 sky130_fd_pr__nfet_01v8 l=0.5u w=0.84u ad=0.1176p as=0.1176p pd=0.28u ps=0.28u nf=1
RM2_g_20 vin_p M2_g_20 34719.6
XM2_20 Y M2_g_20 tail 0 sky130_fd_pr__nfet_01v8 l=0.5u w=0.84u ad=0.1176p as=0.1176p pd=0.28u ps=0.28u nf=1
RM2_g_21 vin_p M2_g_21 34719.6
XM2_21 Y M2_g_21 tail 0 sky130_fd_pr__nfet_01v8 l=0.5u w=0.84u ad=0.1176p as=0.1176p pd=0.28u ps=0.28u nf=1
RM2_g_22 vin_p M2_g_22 34719.6
XM2_22 Y M2_g_22 tail 0 sky130_fd_pr__nfet_01v8 l=0.5u w=0.84u ad=0.1176p as=0.1176p pd=0.28u ps=0.28u nf=1
RM2_g_23 vin_p M2_g_23 34719.6
XM2_23 Y M2_g_23 tail 0 sky130_fd_pr__nfet_01v8 l=0.5u w=0.84u ad=0.1176p as=0.1176p pd=0.28u ps=0.28u nf=1
RM9_g_0 Vg9 M9_g_0 2995.95
XM9_0 Vg9 M9_g_0 0 0 sky130_fd_pr__nfet_01v8 l=0.5u w=1.26u ad=0.1764p as=0.1764p pd=0.28u ps=0.28u nf=1
RM9_g_1 Vg9 M9_g_1 2995.95
XM9_1 Vg9 M9_g_1 0 0 sky130_fd_pr__nfet_01v8 l=0.5u w=1.26u ad=0.1764p as=0.1764p pd=0.28u ps=0.28u nf=1
RM9_g_2 Vg9 M9_g_2 2995.95
XM9_2 Vg9 M9_g_2 0 0 sky130_fd_pr__nfet_01v8 l=0.5u w=1.26u ad=0.1764p as=0.1764p pd=0.28u ps=0.28u nf=1
RM9_g_3 Vg9 M9_g_3 2995.95
XM9_3 Vg9 M9_g_3 0 0 sky130_fd_pr__nfet_01v8 l=0.5u w=1.26u ad=0.1764p as=0.1764p pd=0.28u ps=0.28u nf=1
RM9_g_4 Vg9 M9_g_4 2995.95
XM9_4 Vg9 M9_g_4 0 0 sky130_fd_pr__nfet_01v8 l=0.5u w=1.26u ad=0.1764p as=0.1764p pd=0.28u ps=0.28u nf=1
RM9_g_5 Vg9 M9_g_5 2995.95
XM9_5 Vg9 M9_g_5 0 0 sky130_fd_pr__nfet_01v8 l=0.5u w=1.26u ad=0.1764p as=0.1764p pd=0.28u ps=0.28u nf=1
RM10_g_0 Vg9 M10_g_0 2995.95
XM10_0 Vg10 M10_g_0 0 0 sky130_fd_pr__nfet_01v8 l=0.5u w=1.26u ad=0.1764p as=0.1764p pd=0.28u ps=0.28u nf=1
RM10_g_1 Vg9 M10_g_1 2995.95
XM10_1 Vg10 M10_g_1 0 0 sky130_fd_pr__nfet_01v8 l=0.5u w=1.26u ad=0.1764p as=0.1764p pd=0.28u ps=0.28u nf=1
RM10_g_2 Vg9 M10_g_2 2995.95
XM10_2 Vg10 M10_g_2 0 0 sky130_fd_pr__nfet_01v8 l=0.5u w=1.26u ad=0.1764p as=0.1764p pd=0.28u ps=0.28u nf=1
RM10_g_3 Vg9 M10_g_3 2995.95
XM10_3 Vg10 M10_g_3 0 0 sky130_fd_pr__nfet_01v8 l=0.5u w=1.26u ad=0.1764p as=0.1764p pd=0.28u ps=0.28u nf=1
RM10_g_4 Vg9 M10_g_4 2995.95
XM10_4 Vg10 M10_g_4 0 0 sky130_fd_pr__nfet_01v8 l=0.5u w=1.26u ad=0.1764p as=0.1764p pd=0.28u ps=0.28u nf=1
RM10_g_5 Vg9 M10_g_5 2995.95
XM10_5 Vg10 M10_g_5 0 0 sky130_fd_pr__nfet_01v8 l=0.5u w=1.26u ad=0.1764p as=0.1764p pd=0.28u ps=0.28u nf=1
RM7_g_0 Vg7 M7_g_0 2520.6
XM7_0 Vg7 M7_g_0 Vg9 0 sky130_fd_pr__nfet_01v8 l=0.35u w=1.26u ad=0.1764p as=0.1764p pd=0.28u ps=0.28u nf=1
RM7_g_1 Vg7 M7_g_1 2520.6
XM7_1 Vg7 M7_g_1 Vg9 0 sky130_fd_pr__nfet_01v8 l=0.35u w=1.26u ad=0.1764p as=0.1764p pd=0.28u ps=0.28u nf=1
RM8_g_0 Vg7 M8_g_0 2520.6
XM8_0 out M8_g_0 Vg10 0 sky130_fd_pr__nfet_01v8 l=0.35u w=1.26u ad=0.1764p as=0.1764p pd=0.28u ps=0.28u nf=1
RM8_g_1 Vg7 M8_g_1 2520.6
XM8_1 out M8_g_1 Vg10 0 sky130_fd_pr__nfet_01v8 l=0.35u w=1.26u ad=0.1764p as=0.1764p pd=0.28u ps=0.28u nf=1
RM11_g_0 vb2 M11_g_0 7052.05
XM11_0 tail M11_g_0 0 0 sky130_fd_pr__nfet_01v8 l=1u w=0.84u ad=0.1176p as=0.1176p pd=0.28u ps=0.28u nf=1
RM11_g_1 vb2 M11_g_1 7052.05
XM11_1 tail M11_g_1 0 0 sky130_fd_pr__nfet_01v8 l=1u w=0.84u ad=0.1176p as=0.1176p pd=0.28u ps=0.28u nf=1
RM11_g_2 vb2 M11_g_2 7052.05
XM11_2 tail M11_g_2 0 0 sky130_fd_pr__nfet_01v8 l=1u w=0.84u ad=0.1176p as=0.1176p pd=0.28u ps=0.28u nf=1
RM11_g_3 vb2 M11_g_3 7052.05
XM11_3 tail M11_g_3 0 0 sky130_fd_pr__nfet_01v8 l=1u w=0.84u ad=0.1176p as=0.1176p pd=0.28u ps=0.28u nf=1
RM11_g_4 vb2 M11_g_4 7052.05
XM11_4 tail M11_g_4 0 0 sky130_fd_pr__nfet_01v8 l=1u w=0.84u ad=0.1176p as=0.1176p pd=0.28u ps=0.28u nf=1
RM11_g_5 vb2 M11_g_5 7052.05
XM11_5 tail M11_g_5 0 0 sky130_fd_pr__nfet_01v8 l=1u w=0.84u ad=0.1176p as=0.1176p pd=0.28u ps=0.28u nf=1
RMN_g_0 vb2 MN_g_0 2350.68
XMN_0 vb2 MN_g_0 0 0 sky130_fd_pr__nfet_01v8 l=1u w=0.84u ad=0.1176p as=0.1176p pd=0.28u ps=0.28u nf=1
RMN_g_1 vb2 MN_g_1 2350.68
XMN_1 vb2 MN_g_1 0 0 sky130_fd_pr__nfet_01v8 l=1u w=0.84u ad=0.1176p as=0.1176p pd=0.28u ps=0.28u nf=1
XDUMNinL_0 tail 0 0 0 sky130_fd_pr__nfet_01v8 l=1u w=0.84u ad=0.1176p as=0.2226p pd=0.28u ps=1.37u nf=1
XDUMNinR_0 tail 0 0 0 sky130_fd_pr__nfet_01v8 l=1u w=0.84u ad=0.2226p as=0.1176p pd=1.37u ps=0.28u nf=1
XDUMNcmL_0 Vg7 0 0 0 sky130_fd_pr__nfet_01v8 l=0.5u w=1.26u ad=0.1764p as=0.3339p pd=0.28u ps=1.79u nf=1
XDUMNcmR_0 Vg7 0 0 0 sky130_fd_pr__nfet_01v8 l=0.5u w=1.26u ad=0.3339p as=0.1764p pd=1.79u ps=0.28u nf=1
XDUMPL_0 vdd vdd vdd vdd sky130_fd_pr__pfet_01v8 l=2.5u w=1.65u ad=0.231p as=0.43725p pd=0.28u ps=2.18u nf=1
XDUMPR_0 vdd vdd vdd vdd sky130_fd_pr__pfet_01v8 l=2.5u w=1.65u ad=0.43725p as=0.231p pd=2.18u ps=0.28u nf=1
Ibg vb1 vb2 dc 8.754151549e-06
Vb3 bias3 0 dc 0.521633785
CL out 0 1e-12
Cw_Vg10 Vg10 0 3.67597e-15
Cw_Vg7 Vg7 0 2.1487e-14
Cw_Vg9 Vg9 0 1.0286e-14
Cw_X X 0 1.70953e-14
Cw_Y Y 0 1.6427e-14
Cw_bias3 bias3 0 9.35389e-15
Cw_gnd 0 0 3.09865e-14
Cw_out out 0 1.1712e-14
Cw_tail tail 0 1.00059e-14
Cw_vb1 vb1 0 2.98787e-14
Cw_vb2 vb2 0 1.24501e-14
Cw_vdd vdd 0 2.70687e-14
Cw_vin_n vin_n 0 1.23063e-14
Cw_vin_p vin_p 0 1.28556e-14
Vinp vin_p 0 dc 1.03743212 ac 1
Lfb out vin_n 1e9
Cfb vin_n 0 1
.control
op
print v(vb1) v(vb2) v(tail) v(X) v(Y) v(out) v(Vg7) v(Vg9) v(Vg10) i(Vdd)
print @m.xmp_0.msky130_fd_pr__pfet_01v8[vds] @m.xmp_0.msky130_fd_pr__pfet_01v8[vdsat] @m.xmp_0.msky130_fd_pr__pfet_01v8[id] @m.xmp_0.msky130_fd_pr__pfet_01v8[gm] @m.xmp_0.msky130_fd_pr__pfet_01v8[gds] @m.xmp_0.msky130_fd_pr__pfet_01v8[vgs]
print @m.xm3_0.msky130_fd_pr__pfet_01v8[vds] @m.xm3_0.msky130_fd_pr__pfet_01v8[vdsat] @m.xm3_0.msky130_fd_pr__pfet_01v8[id] @m.xm3_0.msky130_fd_pr__pfet_01v8[gm] @m.xm3_0.msky130_fd_pr__pfet_01v8[gds] @m.xm3_0.msky130_fd_pr__pfet_01v8[vgs]
print @m.xm4_0.msky130_fd_pr__pfet_01v8[vds] @m.xm4_0.msky130_fd_pr__pfet_01v8[vdsat] @m.xm4_0.msky130_fd_pr__pfet_01v8[id] @m.xm4_0.msky130_fd_pr__pfet_01v8[gm] @m.xm4_0.msky130_fd_pr__pfet_01v8[gds] @m.xm4_0.msky130_fd_pr__pfet_01v8[vgs]
print @m.xm5_0.msky130_fd_pr__pfet_01v8[vds] @m.xm5_0.msky130_fd_pr__pfet_01v8[vdsat] @m.xm5_0.msky130_fd_pr__pfet_01v8[id] @m.xm5_0.msky130_fd_pr__pfet_01v8[gm] @m.xm5_0.msky130_fd_pr__pfet_01v8[gds] @m.xm5_0.msky130_fd_pr__pfet_01v8[vgs]
print @m.xm6_0.msky130_fd_pr__pfet_01v8[vds] @m.xm6_0.msky130_fd_pr__pfet_01v8[vdsat] @m.xm6_0.msky130_fd_pr__pfet_01v8[id] @m.xm6_0.msky130_fd_pr__pfet_01v8[gm] @m.xm6_0.msky130_fd_pr__pfet_01v8[gds] @m.xm6_0.msky130_fd_pr__pfet_01v8[vgs]
print @m.xm1_0.msky130_fd_pr__nfet_01v8[vds] @m.xm1_0.msky130_fd_pr__nfet_01v8[vdsat] @m.xm1_0.msky130_fd_pr__nfet_01v8[id] @m.xm1_0.msky130_fd_pr__nfet_01v8[gm] @m.xm1_0.msky130_fd_pr__nfet_01v8[gds] @m.xm1_0.msky130_fd_pr__nfet_01v8[vgs]
print @m.xm2_0.msky130_fd_pr__nfet_01v8[vds] @m.xm2_0.msky130_fd_pr__nfet_01v8[vdsat] @m.xm2_0.msky130_fd_pr__nfet_01v8[id] @m.xm2_0.msky130_fd_pr__nfet_01v8[gm] @m.xm2_0.msky130_fd_pr__nfet_01v8[gds] @m.xm2_0.msky130_fd_pr__nfet_01v8[vgs]
print @m.xm9_0.msky130_fd_pr__nfet_01v8[vds] @m.xm9_0.msky130_fd_pr__nfet_01v8[vdsat] @m.xm9_0.msky130_fd_pr__nfet_01v8[id] @m.xm9_0.msky130_fd_pr__nfet_01v8[gm] @m.xm9_0.msky130_fd_pr__nfet_01v8[gds] @m.xm9_0.msky130_fd_pr__nfet_01v8[vgs]
print @m.xm10_0.msky130_fd_pr__nfet_01v8[vds] @m.xm10_0.msky130_fd_pr__nfet_01v8[vdsat] @m.xm10_0.msky130_fd_pr__nfet_01v8[id] @m.xm10_0.msky130_fd_pr__nfet_01v8[gm] @m.xm10_0.msky130_fd_pr__nfet_01v8[gds] @m.xm10_0.msky130_fd_pr__nfet_01v8[vgs]
print @m.xm7_0.msky130_fd_pr__nfet_01v8[vds] @m.xm7_0.msky130_fd_pr__nfet_01v8[vdsat] @m.xm7_0.msky130_fd_pr__nfet_01v8[id] @m.xm7_0.msky130_fd_pr__nfet_01v8[gm] @m.xm7_0.msky130_fd_pr__nfet_01v8[gds] @m.xm7_0.msky130_fd_pr__nfet_01v8[vgs]
print @m.xm8_0.msky130_fd_pr__nfet_01v8[vds] @m.xm8_0.msky130_fd_pr__nfet_01v8[vdsat] @m.xm8_0.msky130_fd_pr__nfet_01v8[id] @m.xm8_0.msky130_fd_pr__nfet_01v8[gm] @m.xm8_0.msky130_fd_pr__nfet_01v8[gds] @m.xm8_0.msky130_fd_pr__nfet_01v8[vgs]
print @m.xm11_0.msky130_fd_pr__nfet_01v8[vds] @m.xm11_0.msky130_fd_pr__nfet_01v8[vdsat] @m.xm11_0.msky130_fd_pr__nfet_01v8[id] @m.xm11_0.msky130_fd_pr__nfet_01v8[gm] @m.xm11_0.msky130_fd_pr__nfet_01v8[gds] @m.xm11_0.msky130_fd_pr__nfet_01v8[vgs]
print @m.xmn_0.msky130_fd_pr__nfet_01v8[vds] @m.xmn_0.msky130_fd_pr__nfet_01v8[vdsat] @m.xmn_0.msky130_fd_pr__nfet_01v8[id] @m.xmn_0.msky130_fd_pr__nfet_01v8[gm] @m.xmn_0.msky130_fd_pr__nfet_01v8[gds] @m.xmn_0.msky130_fd_pr__nfet_01v8[vgs]
print @m.xdumninl_0.msky130_fd_pr__nfet_01v8[vds] @m.xdumninl_0.msky130_fd_pr__nfet_01v8[vdsat] @m.xdumninl_0.msky130_fd_pr__nfet_01v8[id] @m.xdumninl_0.msky130_fd_pr__nfet_01v8[gm] @m.xdumninl_0.msky130_fd_pr__nfet_01v8[gds] @m.xdumninl_0.msky130_fd_pr__nfet_01v8[vgs]
print @m.xdumninr_0.msky130_fd_pr__nfet_01v8[vds] @m.xdumninr_0.msky130_fd_pr__nfet_01v8[vdsat] @m.xdumninr_0.msky130_fd_pr__nfet_01v8[id] @m.xdumninr_0.msky130_fd_pr__nfet_01v8[gm] @m.xdumninr_0.msky130_fd_pr__nfet_01v8[gds] @m.xdumninr_0.msky130_fd_pr__nfet_01v8[vgs]
print @m.xdumncml_0.msky130_fd_pr__nfet_01v8[vds] @m.xdumncml_0.msky130_fd_pr__nfet_01v8[vdsat] @m.xdumncml_0.msky130_fd_pr__nfet_01v8[id] @m.xdumncml_0.msky130_fd_pr__nfet_01v8[gm] @m.xdumncml_0.msky130_fd_pr__nfet_01v8[gds] @m.xdumncml_0.msky130_fd_pr__nfet_01v8[vgs]
print @m.xdumncmr_0.msky130_fd_pr__nfet_01v8[vds] @m.xdumncmr_0.msky130_fd_pr__nfet_01v8[vdsat] @m.xdumncmr_0.msky130_fd_pr__nfet_01v8[id] @m.xdumncmr_0.msky130_fd_pr__nfet_01v8[gm] @m.xdumncmr_0.msky130_fd_pr__nfet_01v8[gds] @m.xdumncmr_0.msky130_fd_pr__nfet_01v8[vgs]
print @m.xdumpl_0.msky130_fd_pr__pfet_01v8[vds] @m.xdumpl_0.msky130_fd_pr__pfet_01v8[vdsat] @m.xdumpl_0.msky130_fd_pr__pfet_01v8[id] @m.xdumpl_0.msky130_fd_pr__pfet_01v8[gm] @m.xdumpl_0.msky130_fd_pr__pfet_01v8[gds] @m.xdumpl_0.msky130_fd_pr__pfet_01v8[vgs]
print @m.xdumpr_0.msky130_fd_pr__pfet_01v8[vds] @m.xdumpr_0.msky130_fd_pr__pfet_01v8[vdsat] @m.xdumpr_0.msky130_fd_pr__pfet_01v8[id] @m.xdumpr_0.msky130_fd_pr__pfet_01v8[gm] @m.xdumpr_0.msky130_fd_pr__pfet_01v8[gds] @m.xdumpr_0.msky130_fd_pr__pfet_01v8[vgs]
ac dec 100 1 1e10
let a = v(out)/v(vin_p)
let adb = db(a)
let ph = 180*cph(a)/pi
meas ac a0db find adb at=1
meas ac fu when adb=0 cross=1
meas ac phu find ph at=fu
print a0db fu phu
quit
.endc
.end
