* folded_cascode hand design
.include "C:/pdk/sky130_fd_pr/cells/nfet_01v8/sky130_fd_pr__nfet_01v8__tt.pm3.spice"
.include "C:/pdk/sky130_fd_pr/cells/nfet_01v8/sky130_fd_pr__nfet_01v8__mismatch.corner.spice"
.include "C:/pdk/sky130_fd_pr/models/parameters/lod.spice"
.include "C:/pdk/sky130_fd_pr/cells/pfet_01v8/sky130_fd_pr__pfet_01v8__tt.pm3.spice"
.include "C:/pdk/sky130_fd_pr/cells/pfet_01v8/sky130_fd_pr__pfet_01v8__mismatch.corner.spice"
Vdd vdd 0 dc 1.8
XMP_0 vb1 vb1 vdd vdd sky130_fd_pr__pfet_01v8 l=2.5u w=1.65u ad=0.231p as=0.231p pd=0.28u ps=0.28u nf=1
XMP_1 vb1 vb1 vdd vdd sky130_fd_pr__pfet_01v8 l=2.5u w=1.65u ad=0.43725p as=0.231p pd=2.18u ps=0.28u nf=1
XMP_2 vb1 vb1 vdd vdd sky130_fd_pr__pfet_01v8 l=2.5u w=1.65u ad=0.231p as=0.43725p pd=0.28u ps=2.18u nf=1
XMP_3 vb1 vb1 vdd vdd sky130_fd_pr__pfet_01v8 l=2.5u w=1.65u ad=0.231p as=0.231p pd=0.28u ps=0.28u nf=1
XM3_0 X vb1 vdd vdd sky130_fd_pr__pfet_01v8 l=2.5u w=1.65u ad=0.231p as=0.231p pd=0.28u ps=0.28u nf=1
XM3_1 X vb1 vdd vdd sky130_fd_pr__pfet_01v8 l=2.5u w=1.65u ad=0.231p as=0.231p pd=0.28u ps=0.28u nf=1
XM3_2 X vb1 vdd vdd sky130_fd_pr__pfet_01v8 l=2.5u w=1.65u ad=0.231p as=0.231p pd=0.28u ps=0.28u nf=1
XM3_3 X vb1 vdd vdd sky130_fd_pr__pfet_01v8 l=2.5u w=1.65u ad=0.231p as=0.231p pd=0.28u ps=0.28u nf=1
XM3_4 X vb1 vdd vdd sky130_fd_pr__pfet_01v8 l=2.5u w=1.65u ad=0.231p as=0.231p pd=0.28u ps=0.28u nf=1
XM3_5 X vb1 vdd vdd sky130_fd_pr__pfet_01v8 l=2.5u w=1.65u ad=0.231p as=0.231p pd=0.28u ps=0.28u nf=1
XM3_6 X vb1 vdd vdd sky130_fd_pr__pfet_01v8 l=2.5u w=1.65u ad=0.231p as=0.231p pd=0.28u ps=0.28u nf=1
XM3_7 X vb1 vdd vdd sky130_fd_pr__pfet_01v8 l=2.5u w=1.65u ad=0.231p as=0.231p pd=0.28u ps=0.28u nf=1
XM4_0 Y vb1 vdd vdd sky130_fd_pr__pfet_01v8 l=2.5u w=1.65u ad=0.231p as=0.231p pd=0.28u ps=0.28u nf=1
XM4_1 Y vb1 vdd vdd sky130_fd_pr__pfet_01v8 l=2.5u w=1.65u ad=0.231p as=0.231p pd=0.28u ps=0.28u nf=1
XM4_2 Y vb1 vdd vdd sky130_fd_pr__pfet_01v8 l=2.5u w=1.65u ad=0.231p as=0.231p pd=0.28u ps=0.28u nf=1
XM4_3 Y vb1 vdd vdd sky130_fd_pr__pfet_01v8 l=2.5u w=1.65u ad=0.231p as=0.231p pd=0.28u ps=0.28u nf=1
XM4_4 Y vb1 vdd vdd sky130_fd_pr__pfet_01v8 l=2.5u w=1.65u ad=0.231p as=0.231p pd=0.28u ps=0.28u nf=1
XM4_5 Y vb1 vdd vdd sky130_fd_pr__pfet_01v8 l=2.5u w=1.65u ad=0.231p as=0.231p pd=0.28u ps=0.28u nf=1
XM4_6 Y vb1 vdd vdd sky130_fd_pr__pfet_01v8 l=2.5u w=1.65u ad=0.231p as=0.231p pd=0.28u ps=0.28u nf=1
XM4_7 Y vb1 vdd vdd sky130_fd_pr__pfet_01v8 l=2.5u w=1.65u ad=0.231p as=0.231p pd=0.28u ps=0.28u nf=1
XM5_0 Vg7 bias3 Y vdd sky130_fd_pr__pfet_01v8 l=0.5u w=1.65u ad=0.231p as=0.43725p pd=0.28u ps=2.18u nf=1
XM5_1 Vg7 bias3 Y vdd sky130_fd_pr__pfet_01v8 l=0.5u w=1.65u ad=0.231p as=0.231p pd=0.28u ps=0.28u nf=1
XM5_2 Vg7 bias3 Y vdd sky130_fd_pr__pfet_01v8 l=0.5u w=1.65u ad=0.231p as=0.231p pd=0.28u ps=0.28u nf=1
XM5_3 Vg7 bias3 Y vdd sky130_fd_pr__pfet_01v8 l=0.5u w=1.65u ad=0.43725p as=0.231p pd=2.18u ps=0.28u nf=1
XM5_4 Vg7 bias3 Y vdd sky130_fd_pr__pfet_01v8 l=0.5u w=1.65u ad=0.231p as=0.43725p pd=0.28u ps=2.18u nf=1
XM5_5 Vg7 bias3 Y vdd sky130_fd_pr__pfet_01v8 l=0.5u w=1.65u ad=0.231p as=0.231p pd=0.28u ps=0.28u nf=1
XM5_6 Vg7 bias3 Y vdd sky130_fd_pr__pfet_01v8 l=0.5u w=1.65u ad=0.231p as=0.231p pd=0.28u ps=0.28u nf=1
XM5_7 Vg7 bias3 Y vdd sky130_fd_pr__pfet_01v8 l=0.5u w=1.65u ad=0.43725p as=0.231p pd=2.18u ps=0.28u nf=1
XM6_0 out bias3 X vdd sky130_fd_pr__pfet_01v8 l=0.5u w=1.65u ad=0.231p as=0.43725p pd=0.28u ps=2.18u nf=1
XM6_1 out bias3 X vdd sky130_fd_pr__pfet_01v8 l=0.5u w=1.65u ad=0.231p as=0.231p pd=0.28u ps=0.28u nf=1
XM6_2 out bias3 X vdd sky130_fd_pr__pfet_01v8 l=0.5u w=1.65u ad=0.231p as=0.231p pd=0.28u ps=0.28u nf=1
XM6_3 out bias3 X vdd sky130_fd_pr__pfet_01v8 l=0.5u w=1.65u ad=0.231p as=0.231p pd=0.28u ps=0.28u nf=1
XM6_4 out bias3 X vdd sky130_fd_pr__pfet_01v8 l=0.5u w=1.65u ad=0.231p as=0.231p pd=0.28u ps=0.28u nf=1
XM6_5 out bias3 X vdd sky130_fd_pr__pfet_01v8 l=0.5u w=1.65u ad=0.231p as=0.231p pd=0.28u ps=0.28u nf=1
XM6_6 out bias3 X vdd sky130_fd_pr__pfet_01v8 l=0.5u w=1.65u ad=0.231p as=0.231p pd=0.28u ps=0.28u nf=1
XM6_7 out bias3 X vdd sky130_fd_pr__pfet_01v8 l=0.5u w=1.65u ad=0.43725p as=0.231p pd=2.18u ps=0.28u nf=1
XM1_0 X vin_n tail 0 sky130_fd_pr__nfet_01v8 l=0.5u w=0.84u ad=0.1176p as=0.1176p pd=0.28u ps=0.28u nf=1
XM1_1 X vin_n tail 0 sky130_fd_pr__nfet_01v8 l=0.5u w=0.84u ad=0.1176p as=0.1176p pd=0.28u ps=0.28u nf=1
XM1_2 X vin_n tail 0 sky130_fd_pr__nfet_01v8 l=0.5u w=0.84u ad=0.1176p as=0.1176p pd=0.28u ps=0.28u nf=1
XM1_3 X vin_n tail 0 sky130_fd_pr__nfet_01v8 l=0.5u w=0.84u ad=0.1176p as=0.1176p pd=0.28u ps=0.28u nf=1
XM1_4 X vin_n tail 0 sky130_fd_pr__nfet_01v8 l=0.5u w=0.84u ad=0.1176p as=0.1176p pd=0.28u ps=0.28u nf=1
XM1_5 X vin_n tail 0 sky130_fd_pr__nfet_01v8 l=0.5u w=0.84u ad=0.1176p as=0.1176p pd=0.28u ps=0.28u nf=1
XM1_6 X vin_n tail 0 sky130_fd_pr__nfet_01v8 l=0.5u w=0.84u ad=0.1176p as=0.1176p pd=0.28u ps=0.28u nf=1
XM1_7 X vin_n tail 0 sky130_fd_pr__nfet_01v8 l=0.5u w=0.84u ad=0.1176p as=0.1176p pd=0.28u ps=0.28u nf=1
XM1_8 X vin_n tail 0 sky130_fd_pr__nfet_01v8 l=0.5u w=0.84u ad=0.1176p as=0.1176p pd=0.28u ps=0.28u nf=1
XM1_9 X vin_n tail 0 sky130_fd_pr__nfet_01v8 l=0.5u w=0.84u ad=0.1176p as=0.1176p pd=0.28u ps=0.28u nf=1
XM1_10 X vin_n tail 0 sky130_fd_pr__nfet_01v8 l=0.5u w=0.84u ad=0.1176p as=0.1176p pd=0.28u ps=0.28u nf=1
XM1_11 X vin_n tail 0 sky130_fd_pr__nfet_01v8 l=0.5u w=0.84u ad=0.1176p as=0.1176p pd=0.28u ps=0.28u nf=1
XM1_12 X vin_n tail 0 sky130_fd_pr__nfet_01v8 l=0.5u w=0.84u ad=0.1176p as=0.1176p pd=0.28u ps=0.28u nf=1
XM1_13 X vin_n tail 0 sky130_fd_pr__nfet_01v8 l=0.5u w=0.84u ad=0.1176p as=0.1176p pd=0.28u ps=0.28u nf=1
XM1_14 X vin_n tail 0 sky130_fd_pr__nfet_01v8 l=0.5u w=0.84u ad=0.1176p as=0.1176p pd=0.28u ps=0.28u nf=1
XM1_15 X vin_n tail 0 sky130_fd_pr__nfet_01v8 l=0.5u w=0.84u ad=0.1176p as=0.1176p pd=0.28u ps=0.28u nf=1
XM1_16 X vin_n tail 0 sky130_fd_pr__nfet_01v8 l=0.5u w=0.84u ad=0.1176p as=0.1176p pd=0.28u ps=0.28u nf=1
XM1_17 X vin_n tail 0 sky130_fd_pr__nfet_01v8 l=0.5u w=0.84u ad=0.1176p as=0.1176p pd=0.28u ps=0.28u nf=1
XM1_18 X vin_n tail 0 sky130_fd_pr__nfet_01v8 l=0.5u w=0.84u ad=0.1176p as=0.1176p pd=0.28u ps=0.28u nf=1
XM1_19 X vin_n tail 0 sky130_fd_pr__nfet_01v8 l=0.5u w=0.84u ad=0.1176p as=0.1176p pd=0.28u ps=0.28u nf=1
XM1_20 X vin_n tail 0 sky130_fd_pr__nfet_01v8 l=0.5u w=0.84u ad=0.1176p as=0.1176p pd=0.28u ps=0.28u nf=1
XM1_21 X vin_n tail 0 sky130_fd_pr__nfet_01v8 l=0.5u w=0.84u ad=0.1176p as=0.1176p pd=0.28u ps=0.28u nf=1
XM1_22 X vin_n tail 0 sky130_fd_pr__nfet_01v8 l=0.5u w=0.84u ad=0.1176p as=0.1176p pd=0.28u ps=0.28u nf=1
XM1_23 X vin_n tail 0 sky130_fd_pr__nfet_01v8 l=0.5u w=0.84u ad=0.1176p as=0.1176p pd=0.28u ps=0.28u nf=1
XM1_24 X vin_n tail 0 sky130_fd_pr__nfet_01v8 l=0.5u w=0.84u ad=0.1176p as=0.1176p pd=0.28u ps=0.28u nf=1
XM1_25 X vin_n tail 0 sky130_fd_pr__nfet_01v8 l=0.5u w=0.84u ad=0.1176p as=0.1176p pd=0.28u ps=0.28u nf=1
XM2_0 Y vin_p tail 0 sky130_fd_pr__nfet_01v8 l=0.5u w=0.84u ad=0.1176p as=0.2226p pd=0.28u ps=1.37u nf=1
XM2_1 Y vin_p tail 0 sky130_fd_pr__nfet_01v8 l=0.5u w=0.84u ad=0.1176p as=0.1176p pd=0.28u ps=0.28u nf=1
XM2_2 Y vin_p tail 0 sky130_fd_pr__nfet_01v8 l=0.5u w=0.84u ad=0.1176p as=0.1176p pd=0.28u ps=0.28u nf=1
XM2_3 Y vin_p tail 0 sky130_fd_pr__nfet_01v8 l=0.5u w=0.84u ad=0.1176p as=0.1176p pd=0.28u ps=0.28u nf=1
XM2_4 Y vin_p tail 0 sky130_fd_pr__nfet_01v8 l=0.5u w=0.84u ad=0.1176p as=0.1176p pd=0.28u ps=0.28u nf=1
XM2_5 Y vin_p tail 0 sky130_fd_pr__nfet_01v8 l=0.5u w=0.84u ad=0.1176p as=0.1176p pd=0.28u ps=0.28u nf=1
XM2_6 Y vin_p tail 0 sky130_fd_pr__nfet_01v8 l=0.5u w=0.84u ad=0.1176p as=0.1176p pd=0.28u ps=0.28u nf=1
XM2_7 Y vin_p tail 0 sky130_fd_pr__nfet_01v8 l=0.5u w=0.84u ad=0.1176p as=0.1176p pd=0.28u ps=0.28u nf=1
XM2_8 Y vin_p tail 0 sky130_fd_pr__nfet_01v8 l=0.5u w=0.84u ad=0.1176p as=0.1176p pd=0.28u ps=0.28u nf=1
XM2_9 Y vin_p tail 0 sky130_fd_pr__nfet_01v8 l=0.5u w=0.84u ad=0.1176p as=0.1176p pd=0.28u ps=0.28u nf=1
XM2_10 Y vin_p tail 0 sky130_fd_pr__nfet_01v8 l=0.5u w=0.84u ad=0.1176p as=0.1176p pd=0.28u ps=0.28u nf=1
XM2_11 Y vin_p tail 0 sky130_fd_pr__nfet_01v8 l=0.5u w=0.84u ad=0.1176p as=0.1176p pd=0.28u ps=0.28u nf=1
XM2_12 Y vin_p tail 0 sky130_fd_pr__nfet_01v8 l=0.5u w=0.84u ad=0.1176p as=0.1176p pd=0.28u ps=0.28u nf=1
XM2_13 Y vin_p tail 0 sky130_fd_pr__nfet_01v8 l=0.5u w=0.84u ad=0.1176p as=0.1176p pd=0.28u ps=0.28u nf=1
XM2_14 Y vin_p tail 0 sky130_fd_pr__nfet_01v8 l=0.5u w=0.84u ad=0.1176p as=0.1176p pd=0.28u ps=0.28u nf=1
XM2_15 Y vin_p tail 0 sky130_fd_pr__nfet_01v8 l=0.5u w=0.84u ad=0.1176p as=0.1176p pd=0.28u ps=0.28u nf=1
XM2_16 Y vin_p tail 0 sky130_fd_pr__nfet_01v8 l=0.5u w=0.84u ad=0.1176p as=0.1176p pd=0.28u ps=0.28u nf=1
XM2_17 Y vin_p tail 0 sky130_fd_pr__nfet_01v8 l=0.5u w=0.84u ad=0.1176p as=0.1176p pd=0.28u ps=0.28u nf=1
XM2_18 Y vin_p tail 0 sky130_fd_pr__nfet_01v8 l=0.5u w=0.84u ad=0.1176p as=0.1176p pd=0.28u ps=0.28u nf=1
XM2_19 Y vin_p tail 0 sky130_fd_pr__nfet_01v8 l=0.5u w=0.84u ad=0.1176p as=0.1176p pd=0.28u ps=0.28u nf=1
XM2_20 Y vin_p tail 0 sky130_fd_pr__nfet_01v8 l=0.5u w=0.84u ad=0.1176p as=0.1176p pd=0.28u ps=0.28u nf=1
XM2_21 Y vin_p tail 0 sky130_fd_pr__nfet_01v8 l=0.5u w=0.84u ad=0.1176p as=0.1176p pd=0.28u ps=0.28u nf=1
XM2_22 Y vin_p tail 0 sky130_fd_pr__nfet_01v8 l=0.5u w=0.84u ad=0.1176p as=0.1176p pd=0.28u ps=0.28u nf=1
XM2_23 Y vin_p tail 0 sky130_fd_pr__nfet_01v8 l=0.5u w=0.84u ad=0.1176p as=0.1176p pd=0.28u ps=0.28u nf=1
XM2_24 Y vin_p tail 0 sky130_fd_pr__nfet_01v8 l=0.5u w=0.84u ad=0.1176p as=0.1176p pd=0.28u ps=0.28u nf=1
XM2_25 Y vin_p tail 0 sky130_fd_pr__nfet_01v8 l=0.5u w=0.84u ad=0.2226p as=0.1176p pd=1.37u ps=0.28u nf=1
XM9_0 Vg9 Vg9 0 0 sky130_fd_pr__nfet_01v8 l=0.5u w=0.42u ad=0.0588p as=0.0588p pd=0.28u ps=0.28u nf=1
XM9_1 Vg9 Vg9 0 0 sky130_fd_pr__nfet_01v8 l=0.5u w=0.42u ad=0.0588p as=0.0588p pd=0.28u ps=0.28u nf=1
XM9_2 Vg9 Vg9 0 0 sky130_fd_pr__nfet_01v8 l=0.5u w=0.42u ad=0.0588p as=0.0588p pd=0.28u ps=0.28u nf=1
XM9_3 Vg9 Vg9 0 0 sky130_fd_pr__nfet_01v8 l=0.5u w=0.42u ad=0.0588p as=0.0588p pd=0.28u ps=0.28u nf=1
XM9_4 Vg9 Vg9 0 0 sky130_fd_pr__nfet_01v8 l=0.5u w=0.42u ad=0.0588p as=0.0588p pd=0.28u ps=0.28u nf=1
XM9_5 Vg9 Vg9 0 0 sky130_fd_pr__nfet_01v8 l=0.5u w=0.42u ad=0.0588p as=0.0588p pd=0.28u ps=0.28u nf=1
XM9_6 Vg9 Vg9 0 0 sky130_fd_pr__nfet_01v8 l=0.5u w=0.42u ad=0.0588p as=0.0588p pd=0.28u ps=0.28u nf=1
XM9_7 Vg9 Vg9 0 0 sky130_fd_pr__nfet_01v8 l=0.5u w=0.42u ad=0.0588p as=0.0588p pd=0.28u ps=0.28u nf=1
XM9_8 Vg9 Vg9 0 0 sky130_fd_pr__nfet_01v8 l=0.5u w=0.42u ad=0.0588p as=0.0588p pd=0.28u ps=0.28u nf=1
XM9_9 Vg9 Vg9 0 0 sky130_fd_pr__nfet_01v8 l=0.5u w=0.42u ad=0.0588p as=0.0588p pd=0.28u ps=0.28u nf=1
XM9_10 Vg9 Vg9 0 0 sky130_fd_pr__nfet_01v8 l=0.5u w=0.42u ad=0.0588p as=0.0588p pd=0.28u ps=0.28u nf=1
XM9_11 Vg9 Vg9 0 0 sky130_fd_pr__nfet_01v8 l=0.5u w=0.42u ad=0.0588p as=0.0588p pd=0.28u ps=0.28u nf=1
XM9_12 Vg9 Vg9 0 0 sky130_fd_pr__nfet_01v8 l=0.5u w=0.42u ad=0.0588p as=0.0588p pd=0.28u ps=0.28u nf=1
XM9_13 Vg9 Vg9 0 0 sky130_fd_pr__nfet_01v8 l=0.5u w=0.42u ad=0.0588p as=0.0588p pd=0.28u ps=0.28u nf=1
XM9_14 Vg9 Vg9 0 0 sky130_fd_pr__nfet_01v8 l=0.5u w=0.42u ad=0.0588p as=0.0588p pd=0.28u ps=0.28u nf=1
XM9_15 Vg9 Vg9 0 0 sky130_fd_pr__nfet_01v8 l=0.5u w=0.42u ad=0.0588p as=0.0588p pd=0.28u ps=0.28u nf=1
XM9_16 Vg9 Vg9 0 0 sky130_fd_pr__nfet_01v8 l=0.5u w=0.42u ad=0.0588p as=0.0588p pd=0.28u ps=0.28u nf=1
XM9_17 Vg9 Vg9 0 0 sky130_fd_pr__nfet_01v8 l=0.5u w=0.42u ad=0.0588p as=0.0588p pd=0.28u ps=0.28u nf=1
XM10_0 Vg10 Vg9 0 0 sky130_fd_pr__nfet_01v8 l=0.5u w=0.42u ad=0.0588p as=0.0588p pd=0.28u ps=0.28u nf=1
XM10_1 Vg10 Vg9 0 0 sky130_fd_pr__nfet_01v8 l=0.5u w=0.42u ad=0.0588p as=0.0588p pd=0.28u ps=0.28u nf=1
XM10_2 Vg10 Vg9 0 0 sky130_fd_pr__nfet_01v8 l=0.5u w=0.42u ad=0.0588p as=0.0588p pd=0.28u ps=0.28u nf=1
XM10_3 Vg10 Vg9 0 0 sky130_fd_pr__nfet_01v8 l=0.5u w=0.42u ad=0.0588p as=0.0588p pd=0.28u ps=0.28u nf=1
XM10_4 Vg10 Vg9 0 0 sky130_fd_pr__nfet_01v8 l=0.5u w=0.42u ad=0.0588p as=0.0588p pd=0.28u ps=0.28u nf=1
XM10_5 Vg10 Vg9 0 0 sky130_fd_pr__nfet_01v8 l=0.5u w=0.42u ad=0.0588p as=0.0588p pd=0.28u ps=0.28u nf=1
XM10_6 Vg10 Vg9 0 0 sky130_fd_pr__nfet_01v8 l=0.5u w=0.42u ad=0.0588p as=0.0588p pd=0.28u ps=0.28u nf=1
XM10_7 Vg10 Vg9 0 0 sky130_fd_pr__nfet_01v8 l=0.5u w=0.42u ad=0.0588p as=0.0588p pd=0.28u ps=0.28u nf=1
XM10_8 Vg10 Vg9 0 0 sky130_fd_pr__nfet_01v8 l=0.5u w=0.42u ad=0.0588p as=0.0588p pd=0.28u ps=0.28u nf=1
XM10_9 Vg10 Vg9 0 0 sky130_fd_pr__nfet_01v8 l=0.5u w=0.42u ad=0.0588p as=0.0588p pd=0.28u ps=0.28u nf=1
XM10_10 Vg10 Vg9 0 0 sky130_fd_pr__nfet_01v8 l=0.5u w=0.42u ad=0.0588p as=0.0588p pd=0.28u ps=0.28u nf=1
XM10_11 Vg10 Vg9 0 0 sky130_fd_pr__nfet_01v8 l=0.5u w=0.42u ad=0.0588p as=0.0588p pd=0.28u ps=0.28u nf=1
XM10_12 Vg10 Vg9 0 0 sky130_fd_pr__nfet_01v8 l=0.5u w=0.42u ad=0.0588p as=0.0588p pd=0.28u ps=0.28u nf=1
XM10_13 Vg10 Vg9 0 0 sky130_fd_pr__nfet_01v8 l=0.5u w=0.42u ad=0.0588p as=0.0588p pd=0.28u ps=0.28u nf=1
XM10_14 Vg10 Vg9 0 0 sky130_fd_pr__nfet_01v8 l=0.5u w=0.42u ad=0.0588p as=0.0588p pd=0.28u ps=0.28u nf=1
XM10_15 Vg10 Vg9 0 0 sky130_fd_pr__nfet_01v8 l=0.5u w=0.42u ad=0.0588p as=0.0588p pd=0.28u ps=0.28u nf=1
XM10_16 Vg10 Vg9 0 0 sky130_fd_pr__nfet_01v8 l=0.5u w=0.42u ad=0.0588p as=0.0588p pd=0.28u ps=0.28u nf=1
XM10_17 Vg10 Vg9 0 0 sky130_fd_pr__nfet_01v8 l=0.5u w=0.42u ad=0.0588p as=0.0588p pd=0.28u ps=0.28u nf=1
XM7_0 Vg7 Vg7 Vg9 0 sky130_fd_pr__nfet_01v8 l=0.35u w=0.42u ad=0.0588p as=0.0588p pd=0.28u ps=0.28u nf=1
XM7_1 Vg7 Vg7 Vg9 0 sky130_fd_pr__nfet_01v8 l=0.35u w=0.42u ad=0.0588p as=0.0588p pd=0.28u ps=0.28u nf=1
XM7_2 Vg7 Vg7 Vg9 0 sky130_fd_pr__nfet_01v8 l=0.35u w=0.42u ad=0.0588p as=0.0588p pd=0.28u ps=0.28u nf=1
XM7_3 Vg7 Vg7 Vg9 0 sky130_fd_pr__nfet_01v8 l=0.35u w=0.42u ad=0.0588p as=0.0588p pd=0.28u ps=0.28u nf=1
XM7_4 Vg7 Vg7 Vg9 0 sky130_fd_pr__nfet_01v8 l=0.35u w=0.42u ad=0.0588p as=0.0588p pd=0.28u ps=0.28u nf=1
XM7_5 Vg7 Vg7 Vg9 0 sky130_fd_pr__nfet_01v8 l=0.35u w=0.42u ad=0.0588p as=0.0588p pd=0.28u ps=0.28u nf=1
XM7_6 Vg7 Vg7 Vg9 0 sky130_fd_pr__nfet_01v8 l=0.35u w=0.42u ad=0.0588p as=0.0588p pd=0.28u ps=0.28u nf=1
XM7_7 Vg7 Vg7 Vg9 0 sky130_fd_pr__nfet_01v8 l=0.35u w=0.42u ad=0.0588p as=0.0588p pd=0.28u ps=0.28u nf=1
XM7_8 Vg7 Vg7 Vg9 0 sky130_fd_pr__nfet_01v8 l=0.35u w=0.42u ad=0.0588p as=0.0588p pd=0.28u ps=0.28u nf=1
XM7_9 Vg7 Vg7 Vg9 0 sky130_fd_pr__nfet_01v8 l=0.35u w=0.42u ad=0.0588p as=0.0588p pd=0.28u ps=0.28u nf=1
XM7_10 Vg7 Vg7 Vg9 0 sky130_fd_pr__nfet_01v8 l=0.35u w=0.42u ad=0.0588p as=0.0588p pd=0.28u ps=0.28u nf=1
XM7_11 Vg7 Vg7 Vg9 0 sky130_fd_pr__nfet_01v8 l=0.35u w=0.42u ad=0.0588p as=0.0588p pd=0.28u ps=0.28u nf=1
XM7_12 Vg7 Vg7 Vg9 0 sky130_fd_pr__nfet_01v8 l=0.35u w=0.42u ad=0.0588p as=0.0588p pd=0.28u ps=0.28u nf=1
XM7_13 Vg7 Vg7 Vg9 0 sky130_fd_pr__nfet_01v8 l=0.35u w=0.42u ad=0.0588p as=0.0588p pd=0.28u ps=0.28u nf=1
XM7_14 Vg7 Vg7 Vg9 0 sky130_fd_pr__nfet_01v8 l=0.35u w=0.42u ad=0.0588p as=0.0588p pd=0.28u ps=0.28u nf=1
XM7_15 Vg7 Vg7 Vg9 0 sky130_fd_pr__nfet_01v8 l=0.35u w=0.42u ad=0.0588p as=0.0588p pd=0.28u ps=0.28u nf=1
XM7_16 Vg7 Vg7 Vg9 0 sky130_fd_pr__nfet_01v8 l=0.35u w=0.42u ad=0.0588p as=0.0588p pd=0.28u ps=0.28u nf=1
XM7_17 Vg7 Vg7 Vg9 0 sky130_fd_pr__nfet_01v8 l=0.35u w=0.42u ad=0.0588p as=0.0588p pd=0.28u ps=0.28u nf=1
XM7_18 Vg7 Vg7 Vg9 0 sky130_fd_pr__nfet_01v8 l=0.35u w=0.42u ad=0.0588p as=0.0588p pd=0.28u ps=0.28u nf=1
XM7_19 Vg7 Vg7 Vg9 0 sky130_fd_pr__nfet_01v8 l=0.35u w=0.42u ad=0.0588p as=0.0588p pd=0.28u ps=0.28u nf=1
XM7_20 Vg7 Vg7 Vg9 0 sky130_fd_pr__nfet_01v8 l=0.35u w=0.42u ad=0.0588p as=0.0588p pd=0.28u ps=0.28u nf=1
XM7_21 Vg7 Vg7 Vg9 0 sky130_fd_pr__nfet_01v8 l=0.35u w=0.42u ad=0.0588p as=0.0588p pd=0.28u ps=0.28u nf=1
XM7_22 Vg7 Vg7 Vg9 0 sky130_fd_pr__nfet_01v8 l=0.35u w=0.42u ad=0.0588p as=0.0588p pd=0.28u ps=0.28u nf=1
XM7_23 Vg7 Vg7 Vg9 0 sky130_fd_pr__nfet_01v8 l=0.35u w=0.42u ad=0.0588p as=0.0588p pd=0.28u ps=0.28u nf=1
XM7_24 Vg7 Vg7 Vg9 0 sky130_fd_pr__nfet_01v8 l=0.35u w=0.42u ad=0.0588p as=0.0588p pd=0.28u ps=0.28u nf=1
XM7_25 Vg7 Vg7 Vg9 0 sky130_fd_pr__nfet_01v8 l=0.35u w=0.42u ad=0.0588p as=0.0588p pd=0.28u ps=0.28u nf=1
XM7_26 Vg7 Vg7 Vg9 0 sky130_fd_pr__nfet_01v8 l=0.35u w=0.42u ad=0.0588p as=0.0588p pd=0.28u ps=0.28u nf=1
XM7_27 Vg7 Vg7 Vg9 0 sky130_fd_pr__nfet_01v8 l=0.35u w=0.42u ad=0.0588p as=0.0588p pd=0.28u ps=0.28u nf=1
XM8_0 out Vg7 Vg10 0 sky130_fd_pr__nfet_01v8 l=0.35u w=0.42u ad=0.0588p as=0.0588p pd=0.28u ps=0.28u nf=1
XM8_1 out Vg7 Vg10 0 sky130_fd_pr__nfet_01v8 l=0.35u w=0.42u ad=0.0588p as=0.0588p pd=0.28u ps=0.28u nf=1
XM8_2 out Vg7 Vg10 0 sky130_fd_pr__nfet_01v8 l=0.35u w=0.42u ad=0.0588p as=0.0588p pd=0.28u ps=0.28u nf=1
XM8_3 out Vg7 Vg10 0 sky130_fd_pr__nfet_01v8 l=0.35u w=0.42u ad=0.0588p as=0.0588p pd=0.28u ps=0.28u nf=1
XM8_4 out Vg7 Vg10 0 sky130_fd_pr__nfet_01v8 l=0.35u w=0.42u ad=0.0588p as=0.0588p pd=0.28u ps=0.28u nf=1
XM8_5 out Vg7 Vg10 0 sky130_fd_pr__nfet_01v8 l=0.35u w=0.42u ad=0.0588p as=0.0588p pd=0.28u ps=0.28u nf=1
XM8_6 out Vg7 Vg10 0 sky130_fd_pr__nfet_01v8 l=0.35u w=0.42u ad=0.0588p as=0.0588p pd=0.28u ps=0.28u nf=1
XM8_7 out Vg7 Vg10 0 sky130_fd_pr__nfet_01v8 l=0.35u w=0.42u ad=0.0588p as=0.0588p pd=0.28u ps=0.28u nf=1
XM8_8 out Vg7 Vg10 0 sky130_fd_pr__nfet_01v8 l=0.35u w=0.42u ad=0.0588p as=0.0588p pd=0.28u ps=0.28u nf=1
XM8_9 out Vg7 Vg10 0 sky130_fd_pr__nfet_01v8 l=0.35u w=0.42u ad=0.0588p as=0.0588p pd=0.28u ps=0.28u nf=1
XM8_10 out Vg7 Vg10 0 sky130_fd_pr__nfet_01v8 l=0.35u w=0.42u ad=0.0588p as=0.0588p pd=0.28u ps=0.28u nf=1
XM8_11 out Vg7 Vg10 0 sky130_fd_pr__nfet_01v8 l=0.35u w=0.42u ad=0.0588p as=0.0588p pd=0.28u ps=0.28u nf=1
XM8_12 out Vg7 Vg10 0 sky130_fd_pr__nfet_01v8 l=0.35u w=0.42u ad=0.0588p as=0.0588p pd=0.28u ps=0.28u nf=1
XM8_13 out Vg7 Vg10 0 sky130_fd_pr__nfet_01v8 l=0.35u w=0.42u ad=0.0588p as=0.0588p pd=0.28u ps=0.28u nf=1
XM8_14 out Vg7 Vg10 0 sky130_fd_pr__nfet_01v8 l=0.35u w=0.42u ad=0.0588p as=0.0588p pd=0.28u ps=0.28u nf=1
XM8_15 out Vg7 Vg10 0 sky130_fd_pr__nfet_01v8 l=0.35u w=0.42u ad=0.0588p as=0.0588p pd=0.28u ps=0.28u nf=1
XM8_16 out Vg7 Vg10 0 sky130_fd_pr__nfet_01v8 l=0.35u w=0.42u ad=0.0588p as=0.0588p pd=0.28u ps=0.28u nf=1
XM8_17 out Vg7 Vg10 0 sky130_fd_pr__nfet_01v8 l=0.35u w=0.42u ad=0.0588p as=0.0588p pd=0.28u ps=0.28u nf=1
XM8_18 out Vg7 Vg10 0 sky130_fd_pr__nfet_01v8 l=0.35u w=0.42u ad=0.0588p as=0.0588p pd=0.28u ps=0.28u nf=1
XM8_19 out Vg7 Vg10 0 sky130_fd_pr__nfet_01v8 l=0.35u w=0.42u ad=0.0588p as=0.0588p pd=0.28u ps=0.28u nf=1
XM8_20 out Vg7 Vg10 0 sky130_fd_pr__nfet_01v8 l=0.35u w=0.42u ad=0.0588p as=0.0588p pd=0.28u ps=0.28u nf=1
XM8_21 out Vg7 Vg10 0 sky130_fd_pr__nfet_01v8 l=0.35u w=0.42u ad=0.0588p as=0.0588p pd=0.28u ps=0.28u nf=1
XM8_22 out Vg7 Vg10 0 sky130_fd_pr__nfet_01v8 l=0.35u w=0.42u ad=0.0588p as=0.0588p pd=0.28u ps=0.28u nf=1
XM8_23 out Vg7 Vg10 0 sky130_fd_pr__nfet_01v8 l=0.35u w=0.42u ad=0.0588p as=0.0588p pd=0.28u ps=0.28u nf=1
XM8_24 out Vg7 Vg10 0 sky130_fd_pr__nfet_01v8 l=0.35u w=0.42u ad=0.0588p as=0.0588p pd=0.28u ps=0.28u nf=1
XM8_25 out Vg7 Vg10 0 sky130_fd_pr__nfet_01v8 l=0.35u w=0.42u ad=0.0588p as=0.0588p pd=0.28u ps=0.28u nf=1
XM8_26 out Vg7 Vg10 0 sky130_fd_pr__nfet_01v8 l=0.35u w=0.42u ad=0.0588p as=0.0588p pd=0.28u ps=0.28u nf=1
XM8_27 out Vg7 Vg10 0 sky130_fd_pr__nfet_01v8 l=0.35u w=0.42u ad=0.0588p as=0.0588p pd=0.28u ps=0.28u nf=1
XM11_0 tail vb2 0 0 sky130_fd_pr__nfet_01v8 l=1u w=0.84u ad=0.1176p as=0.1176p pd=0.28u ps=0.28u nf=1
XM11_1 tail vb2 0 0 sky130_fd_pr__nfet_01v8 l=1u w=0.84u ad=0.1176p as=0.1176p pd=0.28u ps=0.28u nf=1
XM11_2 tail vb2 0 0 sky130_fd_pr__nfet_01v8 l=1u w=0.84u ad=0.1176p as=0.1176p pd=0.28u ps=0.28u nf=1
XM11_3 tail vb2 0 0 sky130_fd_pr__nfet_01v8 l=1u w=0.84u ad=0.1176p as=0.1176p pd=0.28u ps=0.28u nf=1
XM11_4 tail vb2 0 0 sky130_fd_pr__nfet_01v8 l=1u w=0.84u ad=0.1176p as=0.1176p pd=0.28u ps=0.28u nf=1
XM11_5 tail vb2 0 0 sky130_fd_pr__nfet_01v8 l=1u w=0.84u ad=0.1176p as=0.1176p pd=0.28u ps=0.28u nf=1
XMN_0 vb2 vb2 0 0 sky130_fd_pr__nfet_01v8 l=1u w=0.84u ad=0.2226p as=0.1176p pd=1.37u ps=0.28u nf=1
XMN_1 vb2 vb2 0 0 sky130_fd_pr__nfet_01v8 l=1u w=0.84u ad=0.1176p as=0.2226p pd=0.28u ps=1.37u nf=1
XDUMNinL_0 X 0 0 0 sky130_fd_pr__nfet_01v8 l=1u w=0.84u ad=0.1176p as=0.2226p pd=0.28u ps=1.37u nf=1
XDUMNinR_0 X 0 0 0 sky130_fd_pr__nfet_01v8 l=1u w=0.84u ad=0.2226p as=0.1176p pd=1.37u ps=0.28u nf=1
XDUMNcmL_0 Vg9 0 0 0 sky130_fd_pr__nfet_01v8 l=0.5u w=0.42u ad=0.0588p as=0.1113p pd=0.28u ps=0.95u nf=1
XDUMNcmR_0 Vg9 0 0 0 sky130_fd_pr__nfet_01v8 l=0.5u w=0.42u ad=0.1113p as=0.0588p pd=0.95u ps=0.28u nf=1
XDUMPL_0 vdd vdd vdd vdd sky130_fd_pr__pfet_01v8 l=2.5u w=1.65u ad=0.231p as=0.43725p pd=0.28u ps=2.18u nf=1
XDUMPR_0 vdd vdd vdd vdd sky130_fd_pr__pfet_01v8 l=2.5u w=1.65u ad=0.43725p as=0.231p pd=2.18u ps=0.28u nf=1
Ibg vb1 vb2 dc 7.448533333e-06
Vb3 bias3 0 dc 0.447392
CL out 0 1e-12
Vinp vin_p 0 dc 0.94 ac 1
Lfb out vin_n 1e9
Cfb vin_n 0 1
.control
op
print v(vb1) v(vb2) v(tail) v(X) v(Y) v(out) v(Vg7) v(Vg9) v(Vg10) i(Vdd)
print @m.xmp_0.msky130_fd_pr__pfet_01v8[vds] @m.xmp_0.msky130_fd_pr__pfet_01v8[vdsat] @m.xmp_0.msky130_fd_pr__pfet_01v8[id] @m.xmp_0.msky130_fd_pr__pfet_01v8[gm] @m.xmp_0.msky130_fd_pr__pfet_01v8[gds] @m.xmp_0.msky130_fd_pr__pfet_01v8[vgs]
print @m.xm3_0.msky130_fd_pr__pfet_01v8[vds] @m.xm3_0.msky130_fd_pr__pfet_01v8[vdsat] @m.xm3_0.msky130_fd_pr__pfet_01v8[id] @m.xm3_0.msky130_fd_pr__pfet_01v8[gm] @m.xm3_0.msky130_fd_pr__pfet_01v8[gds] @m.xm3_0.msky130_fd_pr__pfet_01v8[vgs]
print @m.xm4_0.msky130_fd_pr__pfet_01v8[vds] @m.xm4_0.msky130_fd_pr__pfet_01v8[vdsat] @m.xm4_0.msky130_fd_pr__pfet_01v8[id] @m.xm4_0.msky130_fd_pr__pfet_01v8[gm] @m.xm4_0.msky130_fd_pr__pfet_01v8[gds] @m.xm4_0.msky130_fd_pr__pfet_01v8[vgs]
print @m.xm5_0.msky130_fd_pr__pfet_01v8[vds] @m.xm5_0.msky130_fd_pr__pfet_01v8[vdsat] @m.xm5_0.msky130_fd_pr__pfet_01v8[id] @m.xm5_0.msky130_fd_pr__pfet_01v8[gm] @m.xm5_0.msky130_fd_pr__pfet_01v8[gds] @m.xm5_0.msky130_fd_pr__pfet_01v8[vgs]
print @m.xm6_0.msky130_fd_pr__pfet_01v8[vds] @m.xm6_0.msky130_fd_pr__pfet_01v8[vdsat] @m.xm6_0.msky130_fd_pr__pfet_01v8[id] @m.xm6_0.msky130_fd_pr__pfet_01v8[gm] @m.xm6_0.msky130_fd_pr__pfet_01v8[gds] @m.xm6_0.msky130_fd_pr__pfet_01v8[vgs]
print @m.xm1_0.msky130_fd_pr__nfet_01v8[vds] @m.xm1_0.msky130_fd_pr__nfet_01v8[vdsat] @m.xm1_0.msky130_fd_pr__nfet_01v8[id] @m.xm1_0.msky130_fd_pr__nfet_01v8[gm] @m.xm1_0.msky130_fd_pr__nfet_01v8[gds] @m.xm1_0.msky130_fd_pr__nfet_01v8[vgs]
print @m.xm2_0.msky130_fd_pr__nfet_01v8[vds] @m.xm2_0.msky130_fd_pr__nfet_01v8[vdsat] @m.xm2_0.msky130_fd_pr__nfet_01v8[id] @m.xm2_0.msky130_fd_pr__nfet_01v8[gm] @m.xm2_0.msky130_fd_pr__nfet_01v8[gds] @m.xm2_0.msky130_fd_pr__nfet_01v8[vgs]
print @m.xm9_0.msky130_fd_pr__nfet_01v8[vds] @m.xm9_0.msky130_fd_pr__nfet_01v8[vdsat] @m.xm9_0.msky130_fd_pr__nfet_01v8[id] @m.xm9_0.msky130_fd_pr__nfet_01v8[gm] @m.xm9_0.msky130_fd_pr__nfet_01v8[gds] @m.xm9_0.msky130_fd_pr__nfet_01v8[vgs]
print @m.xm10_0.msky130_fd_pr__nfet_01v8[vds] @m.xm10_0.msky130_fd_pr__nfet_01v8[vdsat] @m.xm10_0.msky130_fd_pr__nfet_01v8[id] @m.xm10_0.msky130_fd_pr__nfet_01v8[gm] @m.xm10_0.msky130_fd_pr__nfet_01v8[gds] @m.xm10_0.msky130_fd_pr__nfet_01v8[vgs]
print @m.xm7_0.msky130_fd_pr__nfet_01v8[vds] @m.xm7_0.msky130_fd_pr__nfet_01v8[vdsat] @m.xm7_0.msky130_fd_pr__nfet_01v8[id] @m.xm7_0.msky130_fd_pr__nfet_01v8[gm] @m.xm7_0.msky130_fd_pr__nfet_01v8[gds] @m.xm7_0.msky130_fd_pr__nfet_01v8[vgs]
print @m.xm8_0.msky130_fd_pr__nfet_01v8[vds] @m.xm8_0.msky130_fd_pr__nfet_01v8[vdsat] @m.xm8_0.msky130_fd_pr__nfet_01v8[id] @m.xm8_0.msky130_fd_pr__nfet_01v8[gm] @m.xm8_0.msky130_fd_pr__nfet_01v8[gds] @m.xm8_0.msky130_fd_pr__nfet_01v8[vgs]
print @m.xm11_0.msky130_fd_pr__nfet_01v8[vds] @m.xm11_0.msky130_fd_pr__nfet_01v8[vdsat] @m.xm11_0.msky130_fd_pr__nfet_01v8[id] @m.xm11_0.msky130_fd_pr__nfet_01v8[gm] @m.xm11_0.msky130_fd_pr__nfet_01v8[gds] @m.xm11_0.msky130_fd_pr__nfet_01v8[vgs]
print @m.xmn_0.msky130_fd_pr__nfet_01v8[vds] @m.xmn_0.msky130_fd_pr__nfet_01v8[vdsat] @m.xmn_0.msky130_fd_pr__nfet_01v8[id] @m.xmn_0.msky130_fd_pr__nfet_01v8[gm] @m.xmn_0.msky130_fd_pr__nfet_01v8[gds] @m.xmn_0.msky130_fd_pr__nfet_01v8[vgs]
print @m.xdumninl_0.msky130_fd_pr__nfet_01v8[vds] @m.xdumninl_0.msky130_fd_pr__nfet_01v8[vdsat] @m.xdumninl_0.msky130_fd_pr__nfet_01v8[id] @m.xdumninl_0.msky130_fd_pr__nfet_01v8[gm] @m.xdumninl_0.msky130_fd_pr__nfet_01v8[gds] @m.xdumninl_0.msky130_fd_pr__nfet_01v8[vgs]
print @m.xdumninr_0.msky130_fd_pr__nfet_01v8[vds] @m.xdumninr_0.msky130_fd_pr__nfet_01v8[vdsat] @m.xdumninr_0.msky130_fd_pr__nfet_01v8[id] @m.xdumninr_0.msky130_fd_pr__nfet_01v8[gm] @m.xdumninr_0.msky130_fd_pr__nfet_01v8[gds] @m.xdumninr_0.msky130_fd_pr__nfet_01v8[vgs]
print @m.xdumncml_0.msky130_fd_pr__nfet_01v8[vds] @m.xdumncml_0.msky130_fd_pr__nfet_01v8[vdsat] @m.xdumncml_0.msky130_fd_pr__nfet_01v8[id] @m.xdumncml_0.msky130_fd_pr__nfet_01v8[gm] @m.xdumncml_0.msky130_fd_pr__nfet_01v8[gds] @m.xdumncml_0.msky130_fd_pr__nfet_01v8[vgs]
print @m.xdumncmr_0.msky130_fd_pr__nfet_01v8[vds] @m.xdumncmr_0.msky130_fd_pr__nfet_01v8[vdsat] @m.xdumncmr_0.msky130_fd_pr__nfet_01v8[id] @m.xdumncmr_0.msky130_fd_pr__nfet_01v8[gm] @m.xdumncmr_0.msky130_fd_pr__nfet_01v8[gds] @m.xdumncmr_0.msky130_fd_pr__nfet_01v8[vgs]
print @m.xdumpl_0.msky130_fd_pr__pfet_01v8[vds] @m.xdumpl_0.msky130_fd_pr__pfet_01v8[vdsat] @m.xdumpl_0.msky130_fd_pr__pfet_01v8[id] @m.xdumpl_0.msky130_fd_pr__pfet_01v8[gm] @m.xdumpl_0.msky130_fd_pr__pfet_01v8[gds] @m.xdumpl_0.msky130_fd_pr__pfet_01v8[vgs]
print @m.xdumpr_0.msky130_fd_pr__pfet_01v8[vds] @m.xdumpr_0.msky130_fd_pr__pfet_01v8[vdsat] @m.xdumpr_0.msky130_fd_pr__pfet_01v8[id] @m.xdumpr_0.msky130_fd_pr__pfet_01v8[gm] @m.xdumpr_0.msky130_fd_pr__pfet_01v8[gds] @m.xdumpr_0.msky130_fd_pr__pfet_01v8[vgs]
ac dec 100 1 1e10
let a = v(out)/v(vin_p)
let adb = db(a)
let ph = 180*cph(a)/pi
meas ac a0db find adb at=1
meas ac fu when adb=0 cross=1
meas ac phu find ph at=fu
print a0db fu phu
quit
.endc
.end
