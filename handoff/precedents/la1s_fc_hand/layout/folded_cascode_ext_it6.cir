* Extracted by KLayout with SKY130 LVS runset on : 07/11/2026 11:38

.SUBCKT folded_cascode Vg10 Vg7 Vg9 X Y bias3 gnd out tail vb1 vb2 vdd vin_n
+ vin_p
M$1 out bias3 X vdd sky130_fd_pr__pfet_01v8 L=0.35 W=9.9 AS=1.59225 AD=1.59225
+ PS=13.48 PD=13.48
M$7 Vg7 bias3 Y vdd sky130_fd_pr__pfet_01v8 L=0.35 W=9.9 AS=1.7985 AD=1.7985
+ PS=15.38 PD=15.38
M$10 vdd vdd vdd vdd sky130_fd_pr__pfet_01v8 L=2.5 W=3.3 AS=0.66825 AD=0.66825
+ PS=5.76 PD=5.76
M$11 vdd vb1 X vdd sky130_fd_pr__pfet_01v8 L=2.5 W=13.2 AS=1.848 AD=1.848
+ PS=15.44 PD=15.44
M$15 vdd vb1 Y vdd sky130_fd_pr__pfet_01v8 L=2.5 W=13.2 AS=1.848 AD=1.848
+ PS=15.44 PD=15.44
M$19 vdd vb1 vb1 vdd sky130_fd_pr__pfet_01v8 L=2.5 W=6.6 AS=1.13025 AD=1.13025
+ PS=9.62 PD=9.62
M$35 gnd gnd tail gnd sky130_fd_pr__nfet_01v8 L=1 W=1.68 AS=0.3402 AD=0.3402
+ PS=3.33 PD=3.33
M$36 tail vin_n X gnd sky130_fd_pr__nfet_01v8 L=0.5 W=20.16 AS=2.8224 AD=2.8224
+ PS=26.88 PD=26.88
M$48 tail vin_p Y gnd sky130_fd_pr__nfet_01v8 L=0.5 W=20.16 AS=2.8224 AD=2.8224
+ PS=26.88 PD=26.88
M$60 tail vb2 gnd gnd sky130_fd_pr__nfet_01v8 L=1 W=5.04 AS=0.7056 AD=0.7056
+ PS=6.72 PD=6.72
M$63 gnd vb2 vb2 gnd sky130_fd_pr__nfet_01v8 L=1 W=1.68 AS=0.2352 AD=0.2352
+ PS=2.24 PD=2.24
M$93 gnd gnd Vg7 gnd sky130_fd_pr__nfet_01v8 L=0.5 W=2.52 AS=0.5103 AD=0.5103
+ PS=4.59 PD=4.59
M$94 Vg7 Vg7 Vg9 gnd sky130_fd_pr__nfet_01v8 L=0.35 W=2.52 AS=0.3528 AD=0.3528
+ PS=3.08 PD=3.08
M$95 Vg9 Vg9 gnd gnd sky130_fd_pr__nfet_01v8 L=0.5 W=7.56 AS=1.0584 AD=1.0584
+ PS=9.24 PD=9.24
M$98 gnd Vg9 Vg10 gnd sky130_fd_pr__nfet_01v8 L=0.5 W=7.56 AS=1.0584 AD=1.0584
+ PS=9.24 PD=9.24
M$101 Vg10 Vg7 out gnd sky130_fd_pr__nfet_01v8 L=0.35 W=2.52 AS=0.3528
+ AD=0.3528 PS=3.08 PD=3.08
.ENDS folded_cascode
